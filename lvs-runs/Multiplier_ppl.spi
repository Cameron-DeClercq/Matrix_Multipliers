* +++++++++++++++++++++++++++++++++++++++++++++++++++++++++ *
* CDL Netlist:                                              *
*                                                           *
* Cell Name  : Multiplier_ppl                               *
* Netlisted  : Sun May 11 11:55:26 2025                     *
* Pegasus Version: 22.20-p009 Wed Jan 18 17:06:09 PST 2023  *
* +++++++++++++++++++++++++++++++++++++++++++++++++++++++++ *
*.LDD
*.DEVTMPLT 0 M(g45n1svt) _nmos1v ndiff_conn(D) poly_conn(G) ndiff_conn(S) psubstrate(B)
*.DEVTMPLT 1 M(g45p1svt) _pmos1v pdiff_conn(D) poly_conn(G) pdiff_conn(S) nwell_conn(B)

* +++++++++++++++++++++++++++++++++++++++++++++++++++++++++ *
* Sub cell: nmos1v_CDNS_8                                   *
* +++++++++++++++++++++++++++++++++++++++++++++++++++++++++ *
.subckt nmos1v_CDNS_8 S_source_0 2 D_drain_1 4
** N=4 EP=4 FDC=1
M0 D_drain_1 2 S_source_0 4 g45n1svt w=2.4e-07 l=4.5e-08 ad=3.36e-14 as=3.36e-14 pd=7.6e-07 ps=7.6e-07 sa=1.4e-07 sb=1.4e-07 sca=3.52678 scb=0.000111658 scc=3.66286e-09 fw=2.4e-07 $X=0 $Y=0 $dt=0
.ends nmos1v_CDNS_8

* +++++++++++++++++++++++++++++++++++++++++++++++++++++++++ *
* Sub cell: nmos1v_CDNS_9                                   *
* +++++++++++++++++++++++++++++++++++++++++++++++++++++++++ *
.subckt nmos1v_CDNS_9 S_source_0 D_drain_1 3
** N=3 EP=3 FDC=1
M0 D_drain_1 3 S_source_0 S_source_0 g45n1svt w=1.2e-07 l=4.5e-08 ad=1.68e-14 as=1.68e-14 pd=5.2e-07 ps=5.2e-07 sa=1.4e-07 sb=1.4e-07 sca=3.69959 scb=0.00013007 scc=4.39142e-09 fw=1.2e-07 $X=0 $Y=0 $dt=0
.ends nmos1v_CDNS_9

* +++++++++++++++++++++++++++++++++++++++++++++++++++++++++ *
* Sub cell: Half_Adder                                      *
* +++++++++++++++++++++++++++++++++++++++++++++++++++++++++ *
.subckt Half_Adder B A GND VDD SUM COUT 7 11
*.DEVICECLIMB
** N=13 EP=8 FDC=15
X69 GND 8 12 GND nmos1v_CDNS_8 $T=-2160 -2930 0 0 $X=-2580 $Y=-3130
X70 12 7 SUM GND nmos1v_CDNS_8 $T=-740 -2930 0 0 $X=-1160 $Y=-3130
X71 GND B 13 GND nmos1v_CDNS_8 $T=640 -2930 0 0 $X=220 $Y=-3130
X72 13 A SUM GND nmos1v_CDNS_8 $T=2010 -2930 0 0 $X=1590 $Y=-3130
X73 GND 7 A nmos1v_CDNS_9 $T=-2150 3980 0 0 $X=-2570 $Y=3780
X74 GND 8 B nmos1v_CDNS_9 $T=1510 3980 0 0 $X=1090 $Y=3780
X75 GND COUT 8 nmos1v_CDNS_9 $T=3050 3980 0 0 $X=2630 $Y=3780
X76 GND COUT 7 nmos1v_CDNS_9 $T=4390 3980 0 0 $X=3970 $Y=3780
M0 9 B VDD VDD g45p1svt w=4.8e-07 l=4.5e-08 ad=6.72e-14 as=6.72e-14 pd=1.24e-06 ps=1.24e-06 sa=1.4e-07 sb=1.4e-07 sca=7.67703 scb=0.00492794 scc=0.000127123 fw=4.8e-07 $X=-2160 $Y=-450 $dt=1
M1 7 A VDD VDD g45p1svt w=2.4e-07 l=4.5e-08 ad=3.36e-14 as=3.36e-14 pd=7.6e-07 ps=7.6e-07 sa=1.4e-07 sb=1.4e-07 sca=6.19868 scb=0.00224643 scc=1.06334e-05 fw=2.4e-07 $X=-2150 $Y=1560 $dt=1
M2 SUM 7 9 VDD g45p1svt w=4.8e-07 l=4.5e-08 ad=6.72e-14 as=6.72e-14 pd=1.24e-06 ps=1.24e-06 sa=1.4e-07 sb=1.4e-07 sca=7.2888 scb=0.00480939 scc=0.000127096 fw=4.8e-07 $X=-740 $Y=-450 $dt=1
M3 10 8 VDD VDD g45p1svt w=4.8e-07 l=4.5e-08 ad=6.72e-14 as=6.72e-14 pd=1.24e-06 ps=1.24e-06 sa=1.4e-07 sb=1.4e-07 sca=7.2888 scb=0.00480939 scc=0.000127096 fw=4.8e-07 $X=640 $Y=-450 $dt=1
M4 8 B VDD VDD g45p1svt w=2.4e-07 l=4.5e-08 ad=3.36e-14 as=3.36e-14 pd=7.6e-07 ps=7.6e-07 sa=1.4e-07 sb=1.4e-07 sca=5.82592 scb=0.00213462 scc=1.06087e-05 fw=2.4e-07 $X=1510 $Y=1560 $dt=1
M5 SUM A 10 VDD g45p1svt w=4.8e-07 l=4.5e-08 ad=6.72e-14 as=6.72e-14 pd=1.24e-06 ps=1.24e-06 sa=1.4e-07 sb=1.4e-07 sca=7.2888 scb=0.00480939 scc=0.000127096 fw=4.8e-07 $X=2010 $Y=-450 $dt=1
M6 11 8 VDD VDD g45p1svt w=4.8e-07 l=4.5e-08 ad=6.72e-14 as=6.72e-14 pd=1.24e-06 ps=1.24e-06 sa=1.4e-07 sb=1.4e-07 sca=7.78706 scb=0.00554847 scc=0.000178111 fw=4.8e-07 $X=3050 $Y=1480 $dt=1
.ends Half_Adder

* +++++++++++++++++++++++++++++++++++++++++++++++++++++++++ *
* Sub cell: NAND                                            *
* +++++++++++++++++++++++++++++++++++++++++++++++++++++++++ *
.subckt NAND VDD GND Y B A
*.DEVICECLIMB
** N=6 EP=5 FDC=2
X15 GND A 6 GND nmos1v_CDNS_8 $T=-1580 -500 0 0 $X=-2000 $Y=-700
X16 6 B Y GND nmos1v_CDNS_8 $T=-330 -500 0 0 $X=-750 $Y=-700
.ends NAND

* +++++++++++++++++++++++++++++++++++++++++++++++++++++++++ *
* Sub cell: XOR                                             *
* +++++++++++++++++++++++++++++++++++++++++++++++++++++++++ *
.subckt XOR B A GND VDD Y 6 9
*.DEVICECLIMB
** N=11 EP=7 FDC=10
X52 GND 6 10 GND nmos1v_CDNS_8 $T=-1610 610 0 0 $X=-2030 $Y=410
X53 10 7 Y GND nmos1v_CDNS_8 $T=-190 610 0 0 $X=-610 $Y=410
X54 GND B 11 GND nmos1v_CDNS_8 $T=1190 610 0 0 $X=770 $Y=410
X55 11 A Y GND nmos1v_CDNS_8 $T=2560 610 0 0 $X=2140 $Y=410
X56 GND 7 A nmos1v_CDNS_9 $T=-1600 6860 0 0 $X=-2020 $Y=6660
X57 GND 6 B nmos1v_CDNS_9 $T=2060 6860 0 0 $X=1640 $Y=6660
M0 8 B VDD VDD g45p1svt w=4.8e-07 l=4.5e-08 ad=6.72e-14 as=6.72e-14 pd=1.24e-06 ps=1.24e-06 sa=1.4e-07 sb=1.4e-07 sca=9.47395 scb=0.00759651 scc=0.000374483 fw=4.8e-07 $X=-1610 $Y=3090 $dt=1
M1 7 A VDD VDD g45p1svt w=2.4e-07 l=4.5e-08 ad=3.36e-14 as=3.36e-14 pd=7.6e-07 ps=7.6e-07 sa=1.4e-07 sb=1.4e-07 sca=34.1422 scb=0.0251568 scc=0.00441949 fw=2.4e-07 $X=-1600 $Y=5100 $dt=1
M2 Y 7 8 VDD g45p1svt w=4.8e-07 l=4.5e-08 ad=6.72e-14 as=6.72e-14 pd=1.24e-06 ps=1.24e-06 sa=1.4e-07 sb=1.4e-07 sca=9.47395 scb=0.00759651 scc=0.000374483 fw=4.8e-07 $X=-190 $Y=3090 $dt=1
M3 9 6 VDD VDD g45p1svt w=4.8e-07 l=4.5e-08 ad=6.72e-14 as=6.72e-14 pd=1.24e-06 ps=1.24e-06 sa=1.4e-07 sb=1.4e-07 sca=9.47395 scb=0.00759651 scc=0.000374483 fw=4.8e-07 $X=1190 $Y=3090 $dt=1
.ends XOR

* +++++++++++++++++++++++++++++++++++++++++++++++++++++++++ *
* Sub cell: Full_Adder                                      *
* +++++++++++++++++++++++++++++++++++++++++++++++++++++++++ *
.subckt Full_Adder B A CIN VDD GND SUM COUT 8 9 13
+ 25
*.DEVICECLIMB
** N=25 EP=11 FDC=32
X16 B A GND VDD 9 11 23 XOR $T=-6580 4190 0 0 $X=-9990 $Y=3980
X17 CIN 9 GND VDD SUM 13 25 XOR $T=230 4190 0 0 $X=-3180 $Y=3980
X18 VDD GND 8 A B NAND $T=-6740 420 0 0 $X=-9060 $Y=-820
X19 VDD GND 10 CIN 9 NAND $T=-120 420 0 0 $X=-2440 $Y=-820
X20 VDD GND COUT 8 10 NAND $T=3090 420 0 0 $X=770 $Y=-820
M0 8 A VDD VDD g45p1svt w=2.4e-07 l=4.5e-08 ad=3.36e-14 as=3.36e-14 pd=7.6e-07 ps=7.6e-07 sa=1.4e-07 sb=1.4e-07 sca=20.4324 scb=0.0198648 scc=0.00175929 fw=2.4e-07 $X=-7070 $Y=1800 $dt=1
M1 11 B VDD VDD g45p1svt w=2.4e-07 l=4.5e-08 ad=3.36e-14 as=3.36e-14 pd=7.6e-07 ps=7.6e-07 sa=1.4e-07 sb=1.4e-07 sca=34.1422 scb=0.0251568 scc=0.00441949 fw=2.4e-07 $X=-4520 $Y=9290 $dt=1
M2 9 A 23 VDD g45p1svt w=4.8e-07 l=4.5e-08 ad=6.72e-14 as=6.72e-14 pd=1.24e-06 ps=1.24e-06 sa=1.4e-07 sb=1.4e-07 sca=9.47395 scb=0.00759651 scc=0.000374483 fw=4.8e-07 $X=-4020 $Y=7280 $dt=1
M3 10 9 VDD VDD g45p1svt w=2.4e-07 l=4.5e-08 ad=3.36e-14 as=3.36e-14 pd=7.6e-07 ps=7.6e-07 sa=1.4e-07 sb=1.4e-07 sca=20.4324 scb=0.0198648 scc=0.00175929 fw=2.4e-07 $X=-1700 $Y=1800 $dt=1
M4 10 CIN VDD VDD g45p1svt w=2.4e-07 l=4.5e-08 ad=3.36e-14 as=3.36e-14 pd=7.6e-07 ps=7.6e-07 sa=1.4e-07 sb=1.4e-07 sca=20.4324 scb=0.0198648 scc=0.00175929 fw=2.4e-07 $X=-450 $Y=1800 $dt=1
M5 COUT 10 VDD VDD g45p1svt w=2.4e-07 l=4.5e-08 ad=3.36e-14 as=3.36e-14 pd=7.6e-07 ps=7.6e-07 sa=1.4e-07 sb=1.4e-07 sca=20.4324 scb=0.0198648 scc=0.00175929 fw=2.4e-07 $X=1510 $Y=1800 $dt=1
.ends Full_Adder

* +++++++++++++++++++++++++++++++++++++++++++++++++++++++++ *
* Sub cell: AND                                             *
* +++++++++++++++++++++++++++++++++++++++++++++++++++++++++ *
.subckt AND VDD GND B A Y
** N=7 EP=5 FDC=6
X23 GND A 7 GND nmos1v_CDNS_8 $T=-2110 920 0 0 $X=-2530 $Y=720
X24 7 B 6 GND nmos1v_CDNS_8 $T=-830 920 0 0 $X=-1250 $Y=720
X25 GND Y 6 nmos1v_CDNS_9 $T=420 1020 0 0 $X=0 $Y=820
M0 6 A VDD VDD g45p1svt w=2.4e-07 l=4.5e-08 ad=3.36e-14 as=3.36e-14 pd=7.6e-07 ps=7.6e-07 sa=1.4e-07 sb=1.4e-07 sca=16.0927 scb=0.0154531 scc=0.000419743 fw=2.4e-07 $X=-2110 $Y=2770 $dt=1
M1 6 B VDD VDD g45p1svt w=2.4e-07 l=4.5e-08 ad=3.36e-14 as=3.36e-14 pd=7.6e-07 ps=7.6e-07 sa=1.4e-07 sb=1.4e-07 sca=12.8329 scb=0.0117498 scc=0.000390557 fw=2.4e-07 $X=-830 $Y=2770 $dt=1
M2 Y 6 VDD VDD g45p1svt w=2.4e-07 l=4.5e-08 ad=3.36e-14 as=3.36e-14 pd=7.6e-07 ps=7.6e-07 sa=1.4e-07 sb=1.4e-07 sca=15.9246 scb=0.0151668 scc=0.000414946 fw=2.4e-07 $X=420 $Y=2770 $dt=1
.ends AND

* +++++++++++++++++++++++++++++++++++++++++++++++++++++++++ *
* Sub cell: FlipFlop                                        *
* +++++++++++++++++++++++++++++++++++++++++++++++++++++++++ *
.subckt FlipFlop VDD GND PHI A Y 6 9
*.DEVICECLIMB
** N=11 EP=7 FDC=8
X40 GND A 10 GND nmos1v_CDNS_8 $T=-1260 510 0 0 $X=-1680 $Y=310
X41 10 6 7 GND nmos1v_CDNS_8 $T=-50 510 0 0 $X=-470 $Y=310
X42 GND 7 11 GND nmos1v_CDNS_8 $T=1140 510 0 0 $X=720 $Y=310
X43 11 PHI Y GND nmos1v_CDNS_8 $T=2320 510 0 0 $X=1900 $Y=310
X44 GND 6 PHI nmos1v_CDNS_9 $T=-2500 640 0 0 $X=-2920 $Y=440
M0 8 A VDD VDD g45p1svt w=4.8e-07 l=4.5e-08 ad=6.72e-14 as=6.72e-14 pd=1.24e-06 ps=1.24e-06 sa=1.4e-07 sb=1.4e-07 sca=16.1286 scb=0.0134283 scc=0.00129853 fw=4.8e-07 $X=-1260 $Y=2910 $dt=1
M1 7 PHI 8 VDD g45p1svt w=4.8e-07 l=4.5e-08 ad=6.72e-14 as=6.72e-14 pd=1.24e-06 ps=1.24e-06 sa=1.4e-07 sb=1.4e-07 sca=15.6391 scb=0.0131208 scc=0.00120734 fw=4.8e-07 $X=-50 $Y=2920 $dt=1
M2 9 7 VDD VDD g45p1svt w=4.8e-07 l=4.5e-08 ad=6.72e-14 as=6.72e-14 pd=1.24e-06 ps=1.24e-06 sa=1.4e-07 sb=1.4e-07 sca=16.1286 scb=0.0134283 scc=0.00129853 fw=4.8e-07 $X=1140 $Y=2910 $dt=1
.ends FlipFlop

* +++++++++++++++++++++++++++++++++++++++++++++++++++++++++ *
* Sub cell: Multiplier_ppl                                  *
* +++++++++++++++++++++++++++++++++++++++++++++++++++++++++ *
.subckt Multiplier_ppl A0 A1 A2 A3 B0 B1 B2 B3 GND P0
+ P1 P2 P3 P4 P5 P6 P7 PHI VDD
** N=381 EP=19 FDC=632
X389 8 9 GND VDD P3 28 71 304 Half_Adder $T=-24870 -37710 0 0 $X=-28710 $Y=-41460
X390 10 15 GND VDD 27 14 73 307 Half_Adder $T=-23440 -4410 0 0 $X=-27280 $Y=-8160
X391 11 16 GND VDD 26 29 75 310 Half_Adder $T=-23440 24830 0 0 $X=-27280 $Y=21080
X392 VDD 62 GND VDD P7 66 77 313 Half_Adder $T=18230 -27610 0 0 $X=14390 $Y=-31360
X393 VDD GND 8 18 19 NAND $T=-23460 -29960 0 0 $X=-25780 $Y=-31200
X394 VDD GND 31 36 19 NAND $T=-14180 -29960 0 0 $X=-16500 $Y=-31200
X395 VDD GND 44 49 19 NAND $T=720 -29960 0 0 $X=-1600 $Y=-31200
X396 VDD GND 48 A3 B0 NAND $T=6870 38680 0 0 $X=4550 $Y=37440
X397 VDD GND 61 A3 B1 NAND $T=10150 32510 0 0 $X=7830 $Y=31270
X398 VDD GND 58 51 55 NAND $T=13310 2990 0 0 $X=10990 $Y=1750
X399 31 33 28 VDD GND P4 40 84 80 81
+ 317 Full_Adder $T=-7710 -44360 0 0 $X=-17700 $Y=-45180
X400 23 34 30 VDD GND 9 41 91 87 88
+ 321 Full_Adder $T=-7710 -11450 0 0 $X=-17700 $Y=-12270
X401 32 35 29 VDD GND 15 42 98 94 95
+ 325 Full_Adder $T=-7710 17810 0 0 $X=-17700 $Y=16990
X402 44 46 40 VDD GND P5 52 105 101 102
+ 329 Full_Adder $T=7200 -44360 0 0 $X=-2790 $Y=-45180
X403 38 47 41 VDD GND 33 53 112 108 109
+ 333 Full_Adder $T=7200 -11450 0 0 $X=-2790 $Y=-12270
X404 45 48 42 VDD GND 25 54 119 115 116
+ 337 Full_Adder $T=7200 17810 0 0 $X=-2790 $Y=16990
X405 57 59 52 VDD GND P6 62 126 122 123
+ 341 Full_Adder $T=21450 -44330 0 0 $X=11460 $Y=-45150
X406 58 60 53 VDD GND 46 59 133 129 130
+ 345 Full_Adder $T=21450 -11420 0 0 $X=11460 $Y=-12240
X407 VDD 61 54 VDD GND 39 63 140 136 137
+ 349 Full_Adder $T=21450 17840 0 0 $X=11460 $Y=17020
X408 VDD GND A0 B0 20 AND $T=-25830 37300 0 0 $X=-28870 $Y=37450
X409 VDD GND A0 B2 10 AND $T=-24080 9360 0 0 $X=-27120 $Y=9510
X410 VDD GND A0 B1 11 AND $T=-24080 31190 0 0 $X=-27120 $Y=31340
X411 VDD GND A1 B0 16 AND $T=-18900 37300 0 0 $X=-21940 $Y=37450
X412 VDD GND A1 B2 17 AND $T=-14240 9360 0 0 $X=-17280 $Y=9510
X413 VDD GND A1 B1 32 AND $T=-14240 31190 0 0 $X=-17280 $Y=31340
X414 VDD GND A2 B0 35 AND $T=-9060 37300 0 0 $X=-12100 $Y=37450
X415 VDD GND A2 B2 37 AND $T=690 9360 0 0 $X=-2350 $Y=9510
X416 VDD GND A2 B1 45 AND $T=690 31190 0 0 $X=-2350 $Y=31340
X417 VDD GND 50 19 57 AND $T=7990 -31350 0 0 $X=4950 $Y=-31200
X418 VDD GND PHI B3 19 151 351 FlipFlop $T=-24980 -21210 0 0 $X=-28390 $Y=-21610
X419 VDD GND PHI 17 23 153 353 FlipFlop $T=-22810 2120 0 0 $X=-26220 $Y=1720
X420 VDD GND PHI 14 30 155 355 FlipFlop $T=-22740 -13470 0 0 $X=-26150 $Y=-13870
X421 VDD GND PHI A0 18 157 357 FlipFlop $T=-17920 -21210 0 0 $X=-21330 $Y=-21610
X422 VDD GND PHI 25 34 159 359 FlipFlop $T=-15910 2120 0 0 $X=-19320 $Y=1720
X423 VDD GND PHI A1 36 161 361 FlipFlop $T=-10850 -21210 0 0 $X=-14260 $Y=-21610
X424 VDD GND PHI 37 38 163 363 FlipFlop $T=-8370 2110 0 0 $X=-11780 $Y=1710
X425 VDD GND PHI A2 49 165 365 FlipFlop $T=-3790 -21210 0 0 $X=-7200 $Y=-21610
X426 VDD GND PHI 39 47 167 367 FlipFlop $T=-840 2110 0 0 $X=-4250 $Y=1710
X427 VDD GND PHI A3 50 169 369 FlipFlop $T=3270 -21210 0 0 $X=-140 $Y=-21610
X428 VDD GND PHI A3 51 171 371 FlipFlop $T=6700 2110 0 0 $X=3290 $Y=1710
X429 VDD GND PHI B2 55 173 373 FlipFlop $T=14230 7820 0 0 $X=10820 $Y=7420
X430 VDD GND PHI 27 P2 175 375 FlipFlop $T=17880 -21210 0 0 $X=14470 $Y=-21610
X431 VDD GND PHI 20 P0 177 377 FlipFlop $T=20460 34180 0 0 $X=17050 $Y=33780
X432 VDD GND PHI 63 60 179 379 FlipFlop $T=21760 1690 0 0 $X=18350 $Y=1290
X433 VDD GND PHI 26 P1 181 381 FlipFlop $T=21760 7820 0 0 $X=18350 $Y=7420
M0 151 PHI VDD VDD g45p1svt w=2.4e-07 l=4.5e-08 ad=3.36e-14 as=3.36e-14 pd=7.6e-07 ps=7.6e-07 sa=1.4e-07 sb=1.4e-07 sca=15.0576 scb=0.0142053 scc=0.000386892 fw=2.4e-07 $X=-27480 $Y=-18050 $dt=1
M1 153 PHI VDD VDD g45p1svt w=2.4e-07 l=4.5e-08 ad=3.36e-14 as=3.36e-14 pd=7.6e-07 ps=7.6e-07 sa=1.4e-07 sb=1.4e-07 sca=15.0576 scb=0.0142053 scc=0.000386892 fw=2.4e-07 $X=-25310 $Y=5280 $dt=1
M2 155 PHI VDD VDD g45p1svt w=2.4e-07 l=4.5e-08 ad=3.36e-14 as=3.36e-14 pd=7.6e-07 ps=7.6e-07 sa=1.4e-07 sb=1.4e-07 sca=15.0576 scb=0.0142053 scc=0.000386892 fw=2.4e-07 $X=-25240 $Y=-10310 $dt=1
M3 8 19 VDD VDD g45p1svt w=2.4e-07 l=4.5e-08 ad=3.36e-14 as=3.36e-14 pd=7.6e-07 ps=7.6e-07 sa=1.4e-07 sb=1.4e-07 sca=27.6029 scb=0.0286946 scc=0.00220115 fw=2.4e-07 $X=-25040 $Y=-28580 $dt=1
M4 8 18 VDD VDD g45p1svt w=2.4e-07 l=4.5e-08 ad=3.36e-14 as=3.36e-14 pd=7.6e-07 ps=7.6e-07 sa=1.4e-07 sb=1.4e-07 sca=30.3216 scb=0.0333085 scc=0.0025237 fw=2.4e-07 $X=-23790 $Y=-28580 $dt=1
M5 19 151 351 VDD g45p1svt w=4.8e-07 l=4.5e-08 ad=6.72e-14 as=6.72e-14 pd=1.24e-06 ps=1.24e-06 sa=1.4e-07 sb=1.4e-07 sca=15.6391 scb=0.0131208 scc=0.00120734 fw=4.8e-07 $X=-22660 $Y=-18290 $dt=1
M6 23 153 353 VDD g45p1svt w=4.8e-07 l=4.5e-08 ad=6.72e-14 as=6.72e-14 pd=1.24e-06 ps=1.24e-06 sa=1.4e-07 sb=1.4e-07 sca=15.6391 scb=0.0131208 scc=0.00120734 fw=4.8e-07 $X=-20490 $Y=5040 $dt=1
M7 28 71 304 VDD g45p1svt w=4.8e-07 l=4.5e-08 ad=6.72e-14 as=6.72e-14 pd=1.24e-06 ps=1.24e-06 sa=1.4e-07 sb=1.4e-07 sca=7.78706 scb=0.00554847 scc=0.000178111 fw=4.8e-07 $X=-20480 $Y=-36230 $dt=1
M8 157 PHI VDD VDD g45p1svt w=2.4e-07 l=4.5e-08 ad=3.36e-14 as=3.36e-14 pd=7.6e-07 ps=7.6e-07 sa=1.4e-07 sb=1.4e-07 sca=11.619 scb=0.0101937 scc=0.000351981 fw=2.4e-07 $X=-20420 $Y=-18050 $dt=1
M9 30 155 355 VDD g45p1svt w=4.8e-07 l=4.5e-08 ad=6.72e-14 as=6.72e-14 pd=1.24e-06 ps=1.24e-06 sa=1.4e-07 sb=1.4e-07 sca=18.4233 scb=0.0160258 scc=0.00122435 fw=4.8e-07 $X=-20420 $Y=-10550 $dt=1
M10 14 73 307 VDD g45p1svt w=4.8e-07 l=4.5e-08 ad=6.72e-14 as=6.72e-14 pd=1.24e-06 ps=1.24e-06 sa=1.4e-07 sb=1.4e-07 sca=7.78706 scb=0.00554847 scc=0.000178111 fw=4.8e-07 $X=-19050 $Y=-2930 $dt=1
M11 29 75 310 VDD g45p1svt w=4.8e-07 l=4.5e-08 ad=6.72e-14 as=6.72e-14 pd=1.24e-06 ps=1.24e-06 sa=1.4e-07 sb=1.4e-07 sca=7.78706 scb=0.00554847 scc=0.000178111 fw=4.8e-07 $X=-19050 $Y=26310 $dt=1
M12 159 PHI VDD VDD g45p1svt w=2.4e-07 l=4.5e-08 ad=3.36e-14 as=3.36e-14 pd=7.6e-07 ps=7.6e-07 sa=1.4e-07 sb=1.4e-07 sca=11.619 scb=0.0101937 scc=0.000351981 fw=2.4e-07 $X=-18410 $Y=5280 $dt=1
M13 84 31 VDD VDD g45p1svt w=2.4e-07 l=4.5e-08 ad=3.36e-14 as=3.36e-14 pd=7.6e-07 ps=7.6e-07 sa=1.4e-07 sb=1.4e-07 sca=22.1446 scb=0.0211749 scc=0.0017623 fw=2.4e-07 $X=-16030 $Y=-42560 $dt=1
M14 91 23 VDD VDD g45p1svt w=2.4e-07 l=4.5e-08 ad=3.36e-14 as=3.36e-14 pd=7.6e-07 ps=7.6e-07 sa=1.4e-07 sb=1.4e-07 sca=22.1446 scb=0.0211749 scc=0.0017623 fw=2.4e-07 $X=-16030 $Y=-9650 $dt=1
M15 98 32 VDD VDD g45p1svt w=2.4e-07 l=4.5e-08 ad=3.36e-14 as=3.36e-14 pd=7.6e-07 ps=7.6e-07 sa=1.4e-07 sb=1.4e-07 sca=22.1446 scb=0.0211749 scc=0.0017623 fw=2.4e-07 $X=-16030 $Y=19610 $dt=1
M16 31 19 VDD VDD g45p1svt w=2.4e-07 l=4.5e-08 ad=3.36e-14 as=3.36e-14 pd=7.6e-07 ps=7.6e-07 sa=1.4e-07 sb=1.4e-07 sca=27.6029 scb=0.0286946 scc=0.00220115 fw=2.4e-07 $X=-15760 $Y=-28580 $dt=1
M17 18 157 357 VDD g45p1svt w=4.8e-07 l=4.5e-08 ad=6.72e-14 as=6.72e-14 pd=1.24e-06 ps=1.24e-06 sa=1.4e-07 sb=1.4e-07 sca=15.6391 scb=0.0131208 scc=0.00120734 fw=4.8e-07 $X=-15600 $Y=-18290 $dt=1
M18 31 36 VDD VDD g45p1svt w=2.4e-07 l=4.5e-08 ad=3.36e-14 as=3.36e-14 pd=7.6e-07 ps=7.6e-07 sa=1.4e-07 sb=1.4e-07 sca=30.3216 scb=0.0333085 scc=0.0025237 fw=2.4e-07 $X=-14510 $Y=-28580 $dt=1
M19 34 159 359 VDD g45p1svt w=4.8e-07 l=4.5e-08 ad=6.72e-14 as=6.72e-14 pd=1.24e-06 ps=1.24e-06 sa=1.4e-07 sb=1.4e-07 sca=15.6391 scb=0.0131208 scc=0.00120734 fw=4.8e-07 $X=-13590 $Y=5040 $dt=1
M20 161 PHI VDD VDD g45p1svt w=2.4e-07 l=4.5e-08 ad=3.36e-14 as=3.36e-14 pd=7.6e-07 ps=7.6e-07 sa=1.4e-07 sb=1.4e-07 sca=11.619 scb=0.0101937 scc=0.000351981 fw=2.4e-07 $X=-13350 $Y=-18050 $dt=1
M21 163 PHI VDD VDD g45p1svt w=2.4e-07 l=4.5e-08 ad=3.36e-14 as=3.36e-14 pd=7.6e-07 ps=7.6e-07 sa=1.4e-07 sb=1.4e-07 sca=11.619 scb=0.0101937 scc=0.000351981 fw=2.4e-07 $X=-10870 $Y=5270 $dt=1
M22 36 161 361 VDD g45p1svt w=4.8e-07 l=4.5e-08 ad=6.72e-14 as=6.72e-14 pd=1.24e-06 ps=1.24e-06 sa=1.4e-07 sb=1.4e-07 sca=15.6391 scb=0.0131208 scc=0.00120734 fw=4.8e-07 $X=-8530 $Y=-18290 $dt=1
M23 165 PHI VDD VDD g45p1svt w=2.4e-07 l=4.5e-08 ad=3.36e-14 as=3.36e-14 pd=7.6e-07 ps=7.6e-07 sa=1.4e-07 sb=1.4e-07 sca=11.619 scb=0.0101937 scc=0.000351981 fw=2.4e-07 $X=-6290 $Y=-18050 $dt=1
M24 38 163 363 VDD g45p1svt w=4.8e-07 l=4.5e-08 ad=6.72e-14 as=6.72e-14 pd=1.24e-06 ps=1.24e-06 sa=1.4e-07 sb=1.4e-07 sca=15.6391 scb=0.0131208 scc=0.00120734 fw=4.8e-07 $X=-6050 $Y=5030 $dt=1
M25 81 28 VDD VDD g45p1svt w=2.4e-07 l=4.5e-08 ad=3.36e-14 as=3.36e-14 pd=7.6e-07 ps=7.6e-07 sa=1.4e-07 sb=1.4e-07 sca=34.1422 scb=0.0251568 scc=0.00441949 fw=2.4e-07 $X=-5420 $Y=-35070 $dt=1
M26 88 30 VDD VDD g45p1svt w=2.4e-07 l=4.5e-08 ad=3.36e-14 as=3.36e-14 pd=7.6e-07 ps=7.6e-07 sa=1.4e-07 sb=1.4e-07 sca=34.1422 scb=0.0251568 scc=0.00441949 fw=2.4e-07 $X=-5420 $Y=-2160 $dt=1
M27 95 29 VDD VDD g45p1svt w=2.4e-07 l=4.5e-08 ad=3.36e-14 as=3.36e-14 pd=7.6e-07 ps=7.6e-07 sa=1.4e-07 sb=1.4e-07 sca=34.1422 scb=0.0251568 scc=0.00441949 fw=2.4e-07 $X=-5420 $Y=27100 $dt=1
M28 40 84 VDD VDD g45p1svt w=2.4e-07 l=4.5e-08 ad=3.36e-14 as=3.36e-14 pd=7.6e-07 ps=7.6e-07 sa=1.4e-07 sb=1.4e-07 sca=20.4324 scb=0.0198648 scc=0.00175929 fw=2.4e-07 $X=-4950 $Y=-42560 $dt=1
M29 41 91 VDD VDD g45p1svt w=2.4e-07 l=4.5e-08 ad=3.36e-14 as=3.36e-14 pd=7.6e-07 ps=7.6e-07 sa=1.4e-07 sb=1.4e-07 sca=20.4324 scb=0.0198648 scc=0.00175929 fw=2.4e-07 $X=-4950 $Y=-9650 $dt=1
M30 42 98 VDD VDD g45p1svt w=2.4e-07 l=4.5e-08 ad=3.36e-14 as=3.36e-14 pd=7.6e-07 ps=7.6e-07 sa=1.4e-07 sb=1.4e-07 sca=20.4324 scb=0.0198648 scc=0.00175929 fw=2.4e-07 $X=-4950 $Y=19610 $dt=1
M31 P4 80 317 VDD g45p1svt w=4.8e-07 l=4.5e-08 ad=6.72e-14 as=6.72e-14 pd=1.24e-06 ps=1.24e-06 sa=1.4e-07 sb=1.4e-07 sca=9.47395 scb=0.00759651 scc=0.000374483 fw=4.8e-07 $X=-4920 $Y=-37080 $dt=1
M32 9 87 321 VDD g45p1svt w=4.8e-07 l=4.5e-08 ad=6.72e-14 as=6.72e-14 pd=1.24e-06 ps=1.24e-06 sa=1.4e-07 sb=1.4e-07 sca=9.47395 scb=0.00759651 scc=0.000374483 fw=4.8e-07 $X=-4920 $Y=-4170 $dt=1
M33 15 94 325 VDD g45p1svt w=4.8e-07 l=4.5e-08 ad=6.72e-14 as=6.72e-14 pd=1.24e-06 ps=1.24e-06 sa=1.4e-07 sb=1.4e-07 sca=9.47395 scb=0.00759651 scc=0.000374483 fw=4.8e-07 $X=-4920 $Y=25090 $dt=1
M34 167 PHI VDD VDD g45p1svt w=2.4e-07 l=4.5e-08 ad=3.36e-14 as=3.36e-14 pd=7.6e-07 ps=7.6e-07 sa=1.4e-07 sb=1.4e-07 sca=11.619 scb=0.0101937 scc=0.000351981 fw=2.4e-07 $X=-3340 $Y=5270 $dt=1
M35 49 165 365 VDD g45p1svt w=4.8e-07 l=4.5e-08 ad=6.72e-14 as=6.72e-14 pd=1.24e-06 ps=1.24e-06 sa=1.4e-07 sb=1.4e-07 sca=15.6391 scb=0.0131208 scc=0.00120734 fw=4.8e-07 $X=-1470 $Y=-18290 $dt=1
M36 105 44 VDD VDD g45p1svt w=2.4e-07 l=4.5e-08 ad=3.36e-14 as=3.36e-14 pd=7.6e-07 ps=7.6e-07 sa=1.4e-07 sb=1.4e-07 sca=20.4324 scb=0.0198648 scc=0.00175929 fw=2.4e-07 $X=-1120 $Y=-42560 $dt=1
M37 112 38 VDD VDD g45p1svt w=2.4e-07 l=4.5e-08 ad=3.36e-14 as=3.36e-14 pd=7.6e-07 ps=7.6e-07 sa=1.4e-07 sb=1.4e-07 sca=20.4324 scb=0.0198648 scc=0.00175929 fw=2.4e-07 $X=-1120 $Y=-9650 $dt=1
M38 119 45 VDD VDD g45p1svt w=2.4e-07 l=4.5e-08 ad=3.36e-14 as=3.36e-14 pd=7.6e-07 ps=7.6e-07 sa=1.4e-07 sb=1.4e-07 sca=20.4324 scb=0.0198648 scc=0.00175929 fw=2.4e-07 $X=-1120 $Y=19610 $dt=1
M39 44 19 VDD VDD g45p1svt w=2.4e-07 l=4.5e-08 ad=3.36e-14 as=3.36e-14 pd=7.6e-07 ps=7.6e-07 sa=1.4e-07 sb=1.4e-07 sca=27.6029 scb=0.0286946 scc=0.00220115 fw=2.4e-07 $X=-860 $Y=-28580 $dt=1
M40 44 49 VDD VDD g45p1svt w=2.4e-07 l=4.5e-08 ad=3.36e-14 as=3.36e-14 pd=7.6e-07 ps=7.6e-07 sa=1.4e-07 sb=1.4e-07 sca=30.3216 scb=0.0333085 scc=0.0025237 fw=2.4e-07 $X=390 $Y=-28580 $dt=1
M41 169 PHI VDD VDD g45p1svt w=2.4e-07 l=4.5e-08 ad=3.36e-14 as=3.36e-14 pd=7.6e-07 ps=7.6e-07 sa=1.4e-07 sb=1.4e-07 sca=11.619 scb=0.0101937 scc=0.000351981 fw=2.4e-07 $X=770 $Y=-18050 $dt=1
M42 47 167 367 VDD g45p1svt w=4.8e-07 l=4.5e-08 ad=6.72e-14 as=6.72e-14 pd=1.24e-06 ps=1.24e-06 sa=1.4e-07 sb=1.4e-07 sca=15.6391 scb=0.0131208 scc=0.00120734 fw=4.8e-07 $X=1480 $Y=5030 $dt=1
M43 171 PHI VDD VDD g45p1svt w=2.4e-07 l=4.5e-08 ad=3.36e-14 as=3.36e-14 pd=7.6e-07 ps=7.6e-07 sa=1.4e-07 sb=1.4e-07 sca=11.619 scb=0.0101937 scc=0.000351981 fw=2.4e-07 $X=4200 $Y=5270 $dt=1
M44 48 B0 VDD VDD g45p1svt w=2.4e-07 l=4.5e-08 ad=3.36e-14 as=3.36e-14 pd=7.6e-07 ps=7.6e-07 sa=1.4e-07 sb=1.4e-07 sca=27.6029 scb=0.0286946 scc=0.00220115 fw=2.4e-07 $X=5290 $Y=40060 $dt=1
M45 50 169 369 VDD g45p1svt w=4.8e-07 l=4.5e-08 ad=6.72e-14 as=6.72e-14 pd=1.24e-06 ps=1.24e-06 sa=1.4e-07 sb=1.4e-07 sca=18.4233 scb=0.0160258 scc=0.00122435 fw=4.8e-07 $X=5590 $Y=-18290 $dt=1
M46 48 A3 VDD VDD g45p1svt w=2.4e-07 l=4.5e-08 ad=3.36e-14 as=3.36e-14 pd=7.6e-07 ps=7.6e-07 sa=1.4e-07 sb=1.4e-07 sca=30.3216 scb=0.0333085 scc=0.0025237 fw=2.4e-07 $X=6540 $Y=40060 $dt=1
M47 61 B1 VDD VDD g45p1svt w=2.4e-07 l=4.5e-08 ad=3.36e-14 as=3.36e-14 pd=7.6e-07 ps=7.6e-07 sa=1.4e-07 sb=1.4e-07 sca=27.6029 scb=0.0286946 scc=0.00220115 fw=2.4e-07 $X=8570 $Y=33890 $dt=1
M48 51 171 371 VDD g45p1svt w=4.8e-07 l=4.5e-08 ad=6.72e-14 as=6.72e-14 pd=1.24e-06 ps=1.24e-06 sa=1.4e-07 sb=1.4e-07 sca=15.6482 scb=0.0131226 scc=0.00120734 fw=4.8e-07 $X=9020 $Y=5030 $dt=1
M49 102 40 VDD VDD g45p1svt w=2.4e-07 l=4.5e-08 ad=3.36e-14 as=3.36e-14 pd=7.6e-07 ps=7.6e-07 sa=1.4e-07 sb=1.4e-07 sca=34.1422 scb=0.0251568 scc=0.00441949 fw=2.4e-07 $X=9490 $Y=-35070 $dt=1
M50 109 41 VDD VDD g45p1svt w=2.4e-07 l=4.5e-08 ad=3.36e-14 as=3.36e-14 pd=7.6e-07 ps=7.6e-07 sa=1.4e-07 sb=1.4e-07 sca=34.1422 scb=0.0251568 scc=0.00441949 fw=2.4e-07 $X=9490 $Y=-2160 $dt=1
M51 116 42 VDD VDD g45p1svt w=2.4e-07 l=4.5e-08 ad=3.36e-14 as=3.36e-14 pd=7.6e-07 ps=7.6e-07 sa=1.4e-07 sb=1.4e-07 sca=34.1422 scb=0.0251568 scc=0.00441949 fw=2.4e-07 $X=9490 $Y=27100 $dt=1
M52 61 A3 VDD VDD g45p1svt w=2.4e-07 l=4.5e-08 ad=3.36e-14 as=3.36e-14 pd=7.6e-07 ps=7.6e-07 sa=1.4e-07 sb=1.4e-07 sca=30.3216 scb=0.0333085 scc=0.0025237 fw=2.4e-07 $X=9820 $Y=33890 $dt=1
M53 52 105 VDD VDD g45p1svt w=2.4e-07 l=4.5e-08 ad=3.36e-14 as=3.36e-14 pd=7.6e-07 ps=7.6e-07 sa=1.4e-07 sb=1.4e-07 sca=20.4324 scb=0.0198648 scc=0.00175929 fw=2.4e-07 $X=9960 $Y=-42560 $dt=1
M54 53 112 VDD VDD g45p1svt w=2.4e-07 l=4.5e-08 ad=3.36e-14 as=3.36e-14 pd=7.6e-07 ps=7.6e-07 sa=1.4e-07 sb=1.4e-07 sca=20.4324 scb=0.0198648 scc=0.00175929 fw=2.4e-07 $X=9960 $Y=-9650 $dt=1
M55 54 119 VDD VDD g45p1svt w=2.4e-07 l=4.5e-08 ad=3.36e-14 as=3.36e-14 pd=7.6e-07 ps=7.6e-07 sa=1.4e-07 sb=1.4e-07 sca=20.4324 scb=0.0198648 scc=0.00175929 fw=2.4e-07 $X=9960 $Y=19610 $dt=1
M56 P5 101 329 VDD g45p1svt w=4.8e-07 l=4.5e-08 ad=6.72e-14 as=6.72e-14 pd=1.24e-06 ps=1.24e-06 sa=1.4e-07 sb=1.4e-07 sca=9.47395 scb=0.00759651 scc=0.000374483 fw=4.8e-07 $X=9990 $Y=-37080 $dt=1
M57 33 108 333 VDD g45p1svt w=4.8e-07 l=4.5e-08 ad=6.72e-14 as=6.72e-14 pd=1.24e-06 ps=1.24e-06 sa=1.4e-07 sb=1.4e-07 sca=9.47395 scb=0.00759651 scc=0.000374483 fw=4.8e-07 $X=9990 $Y=-4170 $dt=1
M58 25 115 337 VDD g45p1svt w=4.8e-07 l=4.5e-08 ad=6.72e-14 as=6.72e-14 pd=1.24e-06 ps=1.24e-06 sa=1.4e-07 sb=1.4e-07 sca=9.47395 scb=0.00759651 scc=0.000374483 fw=4.8e-07 $X=9990 $Y=25090 $dt=1
M59 58 55 VDD VDD g45p1svt w=2.4e-07 l=4.5e-08 ad=3.36e-14 as=3.36e-14 pd=7.6e-07 ps=7.6e-07 sa=1.4e-07 sb=1.4e-07 sca=25.5742 scb=0.0258063 scc=0.00214233 fw=2.4e-07 $X=11730 $Y=4370 $dt=1
M60 173 PHI VDD VDD g45p1svt w=2.4e-07 l=4.5e-08 ad=3.36e-14 as=3.36e-14 pd=7.6e-07 ps=7.6e-07 sa=1.4e-07 sb=1.4e-07 sca=15.0576 scb=0.0142053 scc=0.000386892 fw=2.4e-07 $X=11730 $Y=10980 $dt=1
M61 58 51 VDD VDD g45p1svt w=2.4e-07 l=4.5e-08 ad=3.36e-14 as=3.36e-14 pd=7.6e-07 ps=7.6e-07 sa=1.4e-07 sb=1.4e-07 sca=30.3181 scb=0.0333078 scc=0.0025237 fw=2.4e-07 $X=12980 $Y=4370 $dt=1
M62 126 57 VDD VDD g45p1svt w=2.4e-07 l=4.5e-08 ad=3.36e-14 as=3.36e-14 pd=7.6e-07 ps=7.6e-07 sa=1.4e-07 sb=1.4e-07 sca=20.4324 scb=0.0198648 scc=0.00175929 fw=2.4e-07 $X=13130 $Y=-42530 $dt=1
M63 133 58 VDD VDD g45p1svt w=2.4e-07 l=4.5e-08 ad=3.36e-14 as=3.36e-14 pd=7.6e-07 ps=7.6e-07 sa=1.4e-07 sb=1.4e-07 sca=20.4324 scb=0.0198648 scc=0.00175929 fw=2.4e-07 $X=13130 $Y=-9620 $dt=1
M64 140 VDD VDD VDD g45p1svt w=2.4e-07 l=4.5e-08 ad=3.36e-14 as=3.36e-14 pd=7.6e-07 ps=7.6e-07 sa=1.4e-07 sb=1.4e-07 sca=20.4324 scb=0.0198648 scc=0.00175929 fw=2.4e-07 $X=13130 $Y=19640 $dt=1
M65 175 PHI VDD VDD g45p1svt w=2.4e-07 l=4.5e-08 ad=3.36e-14 as=3.36e-14 pd=7.6e-07 ps=7.6e-07 sa=1.4e-07 sb=1.4e-07 sca=15.0576 scb=0.0142053 scc=0.000386892 fw=2.4e-07 $X=15380 $Y=-18050 $dt=1
M66 55 173 373 VDD g45p1svt w=4.8e-07 l=4.5e-08 ad=6.72e-14 as=6.72e-14 pd=1.24e-06 ps=1.24e-06 sa=1.4e-07 sb=1.4e-07 sca=15.6391 scb=0.0131208 scc=0.00120734 fw=4.8e-07 $X=16550 $Y=10740 $dt=1
M67 177 PHI VDD VDD g45p1svt w=2.4e-07 l=4.5e-08 ad=3.36e-14 as=3.36e-14 pd=7.6e-07 ps=7.6e-07 sa=1.4e-07 sb=1.4e-07 sca=15.0576 scb=0.0142053 scc=0.000386892 fw=2.4e-07 $X=17960 $Y=37340 $dt=1
M68 179 PHI VDD VDD g45p1svt w=2.4e-07 l=4.5e-08 ad=3.36e-14 as=3.36e-14 pd=7.6e-07 ps=7.6e-07 sa=1.4e-07 sb=1.4e-07 sca=15.0576 scb=0.0142053 scc=0.000386892 fw=2.4e-07 $X=19260 $Y=4850 $dt=1
M69 181 PHI VDD VDD g45p1svt w=2.4e-07 l=4.5e-08 ad=3.36e-14 as=3.36e-14 pd=7.6e-07 ps=7.6e-07 sa=1.4e-07 sb=1.4e-07 sca=11.619 scb=0.0101937 scc=0.000351981 fw=2.4e-07 $X=19260 $Y=10980 $dt=1
M70 P2 175 375 VDD g45p1svt w=4.8e-07 l=4.5e-08 ad=6.72e-14 as=6.72e-14 pd=1.24e-06 ps=1.24e-06 sa=1.4e-07 sb=1.4e-07 sca=18.4233 scb=0.0160258 scc=0.00122435 fw=4.8e-07 $X=20200 $Y=-18290 $dt=1
M71 66 77 313 VDD g45p1svt w=4.8e-07 l=4.5e-08 ad=6.72e-14 as=6.72e-14 pd=1.24e-06 ps=1.24e-06 sa=1.4e-07 sb=1.4e-07 sca=8.67038 scb=0.00597621 scc=0.000178408 fw=4.8e-07 $X=22620 $Y=-26130 $dt=1
M72 P0 177 377 VDD g45p1svt w=4.8e-07 l=4.5e-08 ad=6.72e-14 as=6.72e-14 pd=1.24e-06 ps=1.24e-06 sa=1.4e-07 sb=1.4e-07 sca=18.4233 scb=0.0160258 scc=0.00122435 fw=4.8e-07 $X=22780 $Y=37100 $dt=1
M73 123 52 VDD VDD g45p1svt w=2.4e-07 l=4.5e-08 ad=3.36e-14 as=3.36e-14 pd=7.6e-07 ps=7.6e-07 sa=1.4e-07 sb=1.4e-07 sca=35.0507 scb=0.0256051 scc=0.00441982 fw=2.4e-07 $X=23740 $Y=-35040 $dt=1
M74 130 53 VDD VDD g45p1svt w=2.4e-07 l=4.5e-08 ad=3.36e-14 as=3.36e-14 pd=7.6e-07 ps=7.6e-07 sa=1.4e-07 sb=1.4e-07 sca=35.0507 scb=0.0256051 scc=0.00441982 fw=2.4e-07 $X=23740 $Y=-2130 $dt=1
M75 137 54 VDD VDD g45p1svt w=2.4e-07 l=4.5e-08 ad=3.36e-14 as=3.36e-14 pd=7.6e-07 ps=7.6e-07 sa=1.4e-07 sb=1.4e-07 sca=35.0507 scb=0.0256051 scc=0.00441982 fw=2.4e-07 $X=23740 $Y=27130 $dt=1
M76 60 179 379 VDD g45p1svt w=4.8e-07 l=4.5e-08 ad=6.72e-14 as=6.72e-14 pd=1.24e-06 ps=1.24e-06 sa=1.4e-07 sb=1.4e-07 sca=18.4233 scb=0.0160258 scc=0.00122435 fw=4.8e-07 $X=24080 $Y=4610 $dt=1
M77 P1 181 381 VDD g45p1svt w=4.8e-07 l=4.5e-08 ad=6.72e-14 as=6.72e-14 pd=1.24e-06 ps=1.24e-06 sa=1.4e-07 sb=1.4e-07 sca=18.4233 scb=0.0160258 scc=0.00122435 fw=4.8e-07 $X=24080 $Y=10740 $dt=1
M78 62 126 VDD VDD g45p1svt w=2.4e-07 l=4.5e-08 ad=3.36e-14 as=3.36e-14 pd=7.6e-07 ps=7.6e-07 sa=1.4e-07 sb=1.4e-07 sca=25.5159 scb=0.0267815 scc=0.00187996 fw=2.4e-07 $X=24210 $Y=-42530 $dt=1
M79 59 133 VDD VDD g45p1svt w=2.4e-07 l=4.5e-08 ad=3.36e-14 as=3.36e-14 pd=7.6e-07 ps=7.6e-07 sa=1.4e-07 sb=1.4e-07 sca=25.5159 scb=0.0267815 scc=0.00187996 fw=2.4e-07 $X=24210 $Y=-9620 $dt=1
M80 63 140 VDD VDD g45p1svt w=2.4e-07 l=4.5e-08 ad=3.36e-14 as=3.36e-14 pd=7.6e-07 ps=7.6e-07 sa=1.4e-07 sb=1.4e-07 sca=25.5159 scb=0.0267815 scc=0.00187996 fw=2.4e-07 $X=24210 $Y=19640 $dt=1
M81 P6 122 341 VDD g45p1svt w=4.8e-07 l=4.5e-08 ad=6.72e-14 as=6.72e-14 pd=1.24e-06 ps=1.24e-06 sa=1.4e-07 sb=1.4e-07 sca=12.8218 scb=0.0114511 scc=0.000406405 fw=4.8e-07 $X=24240 $Y=-37050 $dt=1
M82 46 129 345 VDD g45p1svt w=4.8e-07 l=4.5e-08 ad=6.72e-14 as=6.72e-14 pd=1.24e-06 ps=1.24e-06 sa=1.4e-07 sb=1.4e-07 sca=12.8218 scb=0.0114511 scc=0.000406405 fw=4.8e-07 $X=24240 $Y=-4140 $dt=1
M83 39 136 349 VDD g45p1svt w=4.8e-07 l=4.5e-08 ad=6.72e-14 as=6.72e-14 pd=1.24e-06 ps=1.24e-06 sa=1.4e-07 sb=1.4e-07 sca=12.8218 scb=0.0114511 scc=0.000406405 fw=4.8e-07 $X=24240 $Y=25120 $dt=1
.ends Multiplier_ppl
