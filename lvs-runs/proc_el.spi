* +++++++++++++++++++++++++++++++++++++++++++++++++++++++++ *
* CDL Netlist:                                              *
*                                                           *
* Cell Name  : proc_el                                      *
* Netlisted  : Thu May  8 15:11:20 2025                     *
* Pegasus Version: 22.20-p009 Wed Jan 18 17:06:09 PST 2023  *
* +++++++++++++++++++++++++++++++++++++++++++++++++++++++++ *
*.LDD
*.DEVTMPLT 0 M(g45n1svt) _nmos1v ndiff_conn(D) poly_conn(G) ndiff_conn(S) psubstrate(B)
*.DEVTMPLT 1 M(g45p1svt) _pmos1v pdiff_conn(D) poly_conn(G) pdiff_conn(S) nwell_conn(B)

* +++++++++++++++++++++++++++++++++++++++++++++++++++++++++ *
* Sub cell: nmos1v_CDNS_9                                   *
* +++++++++++++++++++++++++++++++++++++++++++++++++++++++++ *
.subckt nmos1v_CDNS_9 S_source_0 D_drain_1 3
** N=3 EP=3 FDC=1
M0 D_drain_1 3 S_source_0 S_source_0 g45n1svt w=1.2e-07 l=4.5e-08 ad=1.68e-14 as=1.68e-14 pd=5.2e-07 ps=5.2e-07 sa=1.4e-07 sb=1.4e-07 sca=3.69959 scb=0.00013007 scc=4.39142e-09 fw=1.2e-07 $X=0 $Y=0 $dt=0
.ends nmos1v_CDNS_9

* +++++++++++++++++++++++++++++++++++++++++++++++++++++++++ *
* Sub cell: FlipFlop                                        *
* +++++++++++++++++++++++++++++++++++++++++++++++++++++++++ *
.subckt FlipFlop VDD GND A PHI 5 Y 7 8 9 11
*.DEVICECLIMB
** N=11 EP=10 FDC=4
X44 GND 7 PHI nmos1v_CDNS_9 $T=-2500 640 0 0 $X=-2920 $Y=440
M0 10 A GND GND g45n1svt w=2.4e-07 l=4.5e-08 ad=3.36e-14 as=3.36e-14 pd=7.6e-07 ps=7.6e-07 sa=1.4e-07 sb=1.4e-07 sca=3.52678 scb=0.000111658 scc=3.66286e-09 fw=2.4e-07 $X=-1260 $Y=510 $dt=0
M1 5 7 10 GND g45n1svt w=2.4e-07 l=4.5e-08 ad=3.36e-14 as=3.36e-14 pd=7.6e-07 ps=7.6e-07 sa=1.4e-07 sb=1.4e-07 sca=3.52678 scb=0.000111658 scc=3.66286e-09 fw=2.4e-07 $X=-50 $Y=510 $dt=0
M2 11 5 GND GND g45n1svt w=2.4e-07 l=4.5e-08 ad=3.36e-14 as=3.36e-14 pd=7.6e-07 ps=7.6e-07 sa=1.4e-07 sb=1.4e-07 sca=3.52678 scb=0.000111658 scc=3.66286e-09 fw=2.4e-07 $X=1140 $Y=510 $dt=0
.ends FlipFlop

* +++++++++++++++++++++++++++++++++++++++++++++++++++++++++ *
* Sub cell: NAND                                            *
* +++++++++++++++++++++++++++++++++++++++++++++++++++++++++ *
.subckt NAND VDD GND Y B A
*.DEVICECLIMB
** N=6 EP=5 FDC=2
M0 6 A GND GND g45n1svt w=2.4e-07 l=4.5e-08 ad=3.36e-14 as=3.36e-14 pd=7.6e-07 ps=7.6e-07 sa=1.4e-07 sb=1.4e-07 sca=3.52678 scb=0.000111658 scc=3.66286e-09 fw=2.4e-07 $X=-1580 $Y=-500 $dt=0
M1 Y B 6 GND g45n1svt w=2.4e-07 l=4.5e-08 ad=3.36e-14 as=3.36e-14 pd=7.6e-07 ps=7.6e-07 sa=1.4e-07 sb=1.4e-07 sca=3.52678 scb=0.000111658 scc=3.66286e-09 fw=2.4e-07 $X=-330 $Y=-500 $dt=0
.ends NAND

* +++++++++++++++++++++++++++++++++++++++++++++++++++++++++ *
* Sub cell: XOR                                             *
* +++++++++++++++++++++++++++++++++++++++++++++++++++++++++ *
.subckt XOR B A GND VDD Y 6 7 8 9
*.DEVICECLIMB
** N=11 EP=9 FDC=8
X56 GND 7 A nmos1v_CDNS_9 $T=-1600 6860 0 0 $X=-2020 $Y=6660
X57 GND 6 B nmos1v_CDNS_9 $T=2060 6860 0 0 $X=1640 $Y=6660
M0 10 6 GND GND g45n1svt w=2.4e-07 l=4.5e-08 ad=3.36e-14 as=3.36e-14 pd=7.6e-07 ps=7.6e-07 sa=1.4e-07 sb=1.4e-07 sca=3.52678 scb=0.000111658 scc=3.66286e-09 fw=2.4e-07 $X=-1610 $Y=610 $dt=0
M1 Y 7 10 GND g45n1svt w=2.4e-07 l=4.5e-08 ad=3.36e-14 as=3.36e-14 pd=7.6e-07 ps=7.6e-07 sa=1.4e-07 sb=1.4e-07 sca=3.52678 scb=0.000111658 scc=3.66286e-09 fw=2.4e-07 $X=-190 $Y=610 $dt=0
M2 11 B GND GND g45n1svt w=2.4e-07 l=4.5e-08 ad=3.36e-14 as=3.36e-14 pd=7.6e-07 ps=7.6e-07 sa=1.4e-07 sb=1.4e-07 sca=3.52678 scb=0.000111658 scc=3.66286e-09 fw=2.4e-07 $X=1190 $Y=610 $dt=0
M3 Y A 11 GND g45n1svt w=2.4e-07 l=4.5e-08 ad=3.36e-14 as=3.36e-14 pd=7.6e-07 ps=7.6e-07 sa=1.4e-07 sb=1.4e-07 sca=3.52678 scb=0.000111658 scc=3.66286e-09 fw=2.4e-07 $X=2560 $Y=610 $dt=0
M4 Y 7 8 VDD g45p1svt w=4.8e-07 l=4.5e-08 ad=6.72e-14 as=6.72e-14 pd=1.24e-06 ps=1.24e-06 sa=1.4e-07 sb=1.4e-07 sca=9.47395 scb=0.00759651 scc=0.000374483 fw=4.8e-07 $X=-190 $Y=3090 $dt=1
M5 9 6 VDD VDD g45p1svt w=4.8e-07 l=4.5e-08 ad=6.72e-14 as=6.72e-14 pd=1.24e-06 ps=1.24e-06 sa=1.4e-07 sb=1.4e-07 sca=9.47395 scb=0.00759651 scc=0.000374483 fw=4.8e-07 $X=1190 $Y=3090 $dt=1
.ends XOR

* +++++++++++++++++++++++++++++++++++++++++++++++++++++++++ *
* Sub cell: Full_Adder                                      *
* +++++++++++++++++++++++++++++++++++++++++++++++++++++++++ *
.subckt Full_Adder B A VDD GND CIN SUM COUT 8 9 10
+ 12 13 22 25
*.DEVICECLIMB
** N=25 EP=14 FDC=26
X16 B A GND VDD 9 11 12 22 23 XOR $T=-6580 4190 0 0 $X=-9990 $Y=3980
X17 CIN 9 GND VDD SUM 13 14 24 25 XOR $T=230 4190 0 0 $X=-3180 $Y=3980
X18 VDD GND 8 A B NAND $T=-6740 420 0 0 $X=-9060 $Y=-820
X19 VDD GND 10 CIN 9 NAND $T=-120 420 0 0 $X=-2440 $Y=-820
X20 VDD GND COUT 8 10 NAND $T=3090 420 0 0 $X=770 $Y=-820
M0 11 B VDD VDD g45p1svt w=2.4e-07 l=4.5e-08 ad=3.36e-14 as=3.36e-14 pd=7.6e-07 ps=7.6e-07 sa=1.4e-07 sb=1.4e-07 sca=34.1422 scb=0.0251568 scc=0.00441949 fw=2.4e-07 $X=-4520 $Y=9290 $dt=1
M1 9 A 23 VDD g45p1svt w=4.8e-07 l=4.5e-08 ad=6.72e-14 as=6.72e-14 pd=1.24e-06 ps=1.24e-06 sa=1.4e-07 sb=1.4e-07 sca=9.47395 scb=0.00759651 scc=0.000374483 fw=4.8e-07 $X=-4020 $Y=7280 $dt=1
M2 24 CIN VDD VDD g45p1svt w=4.8e-07 l=4.5e-08 ad=6.72e-14 as=6.72e-14 pd=1.24e-06 ps=1.24e-06 sa=1.4e-07 sb=1.4e-07 sca=9.47395 scb=0.00759651 scc=0.000374483 fw=4.8e-07 $X=-1380 $Y=7280 $dt=1
M3 14 9 VDD VDD g45p1svt w=2.4e-07 l=4.5e-08 ad=3.36e-14 as=3.36e-14 pd=7.6e-07 ps=7.6e-07 sa=1.4e-07 sb=1.4e-07 sca=34.1422 scb=0.0251568 scc=0.00441949 fw=2.4e-07 $X=-1370 $Y=9290 $dt=1
.ends Full_Adder

* +++++++++++++++++++++++++++++++++++++++++++++++++++++++++ *
* Sub cell: inv                                             *
* +++++++++++++++++++++++++++++++++++++++++++++++++++++++++ *
.subckt inv VDD GND A Y
** N=4 EP=4 FDC=2
X10 GND Y A nmos1v_CDNS_9 $T=-90 135 0 0 $X=-510 $Y=-65
M0 Y A VDD VDD g45p1svt w=2.4e-07 l=4.5e-08 ad=3.36e-14 as=3.36e-14 pd=7.6e-07 ps=7.6e-07 sa=1.4e-07 sb=1.4e-07 sca=27.9284 scb=0.0232624 scc=0.00337691 fw=2.4e-07 $X=-90 $Y=1620 $dt=1
.ends inv

* +++++++++++++++++++++++++++++++++++++++++++++++++++++++++ *
* Sub cell: faabs                                           *
* +++++++++++++++++++++++++++++++++++++++++++++++++++++++++ *
.subckt faabs SOUT CIN COUT GND VDD A RST PHI 11 14
+ 19 20 31 36
*.DEVICECLIMB
** N=36 EP=14 FDC=48
X19 VDD GND 10 9 RST NAND $T=3320 930 0 0 $X=1000 $Y=-310
X20 SOUT A VDD GND CIN 9 COUT 19 15 18
+ 14 16 31 34 Full_Adder $T=-3810 600 0 0 $X=-13800 $Y=-220
X21 VDD GND 11 SOUT inv $T=6090 430 0 0 $X=4850 $Y=-250
X22 VDD GND 10 PHI 12 11 20 35 36 29 FlipFlop $T=4300 4980 0 0 $X=890 $Y=4580
M0 11 PHI 29 GND g45n1svt w=2.4e-07 l=4.5e-08 ad=3.36e-14 as=3.36e-14 pd=7.6e-07 ps=7.6e-07 sa=1.4e-07 sb=1.4e-07 sca=3.52678 scb=0.000111658 scc=3.66286e-09 fw=2.4e-07 $X=6620 $Y=5490 $dt=0
M1 19 A VDD VDD g45p1svt w=2.4e-07 l=4.5e-08 ad=3.36e-14 as=3.36e-14 pd=7.6e-07 ps=7.6e-07 sa=1.4e-07 sb=1.4e-07 sca=13.9617 scb=0.0132915 scc=0.000629907 fw=2.4e-07 $X=-10880 $Y=2400 $dt=1
M2 18 15 VDD VDD g45p1svt w=2.4e-07 l=4.5e-08 ad=3.36e-14 as=3.36e-14 pd=7.6e-07 ps=7.6e-07 sa=1.4e-07 sb=1.4e-07 sca=13.9617 scb=0.0132915 scc=0.000629907 fw=2.4e-07 $X=-5510 $Y=2400 $dt=1
M3 18 CIN VDD VDD g45p1svt w=2.4e-07 l=4.5e-08 ad=3.36e-14 as=3.36e-14 pd=7.6e-07 ps=7.6e-07 sa=1.4e-07 sb=1.4e-07 sca=13.9617 scb=0.0132915 scc=0.000629907 fw=2.4e-07 $X=-4260 $Y=2400 $dt=1
M4 COUT 18 VDD VDD g45p1svt w=2.4e-07 l=4.5e-08 ad=3.36e-14 as=3.36e-14 pd=7.6e-07 ps=7.6e-07 sa=1.4e-07 sb=1.4e-07 sca=13.9617 scb=0.0132915 scc=0.000629907 fw=2.4e-07 $X=-2300 $Y=2400 $dt=1
M5 16 CIN VDD VDD g45p1svt w=2.4e-07 l=4.5e-08 ad=3.36e-14 as=3.36e-14 pd=7.6e-07 ps=7.6e-07 sa=1.4e-07 sb=1.4e-07 sca=34.1422 scb=0.0251568 scc=0.00441949 fw=2.4e-07 $X=-1520 $Y=9890 $dt=1
M6 COUT 19 VDD VDD g45p1svt w=2.4e-07 l=4.5e-08 ad=3.36e-14 as=3.36e-14 pd=7.6e-07 ps=7.6e-07 sa=1.4e-07 sb=1.4e-07 sca=13.9617 scb=0.0132915 scc=0.000629907 fw=2.4e-07 $X=-1050 $Y=2400 $dt=1
M7 9 15 34 VDD g45p1svt w=4.8e-07 l=4.5e-08 ad=6.72e-14 as=6.72e-14 pd=1.24e-06 ps=1.24e-06 sa=1.4e-07 sb=1.4e-07 sca=9.47395 scb=0.00759651 scc=0.000374483 fw=4.8e-07 $X=-1020 $Y=7880 $dt=1
M8 10 RST VDD VDD g45p1svt w=2.4e-07 l=4.5e-08 ad=3.36e-14 as=3.36e-14 pd=7.6e-07 ps=7.6e-07 sa=1.4e-07 sb=1.4e-07 sca=17.3073 scb=0.0169295 scc=0.00128868 fw=2.4e-07 $X=1740 $Y=2310 $dt=1
M9 20 PHI VDD VDD g45p1svt w=2.4e-07 l=4.5e-08 ad=3.36e-14 as=3.36e-14 pd=7.6e-07 ps=7.6e-07 sa=1.4e-07 sb=1.4e-07 sca=10.0441 scb=0.00891249 scc=0.000296773 fw=2.4e-07 $X=1800 $Y=8140 $dt=1
M10 10 9 VDD VDD g45p1svt w=2.4e-07 l=4.5e-08 ad=3.36e-14 as=3.36e-14 pd=7.6e-07 ps=7.6e-07 sa=1.4e-07 sb=1.4e-07 sca=17.3073 scb=0.0169295 scc=0.00128868 fw=2.4e-07 $X=2990 $Y=2310 $dt=1
M11 35 10 VDD VDD g45p1svt w=4.8e-07 l=4.5e-08 ad=6.72e-14 as=6.72e-14 pd=1.24e-06 ps=1.24e-06 sa=1.4e-07 sb=1.4e-07 sca=13.8415 scb=0.0117975 scc=0.0011174 fw=4.8e-07 $X=3040 $Y=7890 $dt=1
M12 12 PHI 35 VDD g45p1svt w=4.8e-07 l=4.5e-08 ad=6.72e-14 as=6.72e-14 pd=1.24e-06 ps=1.24e-06 sa=1.4e-07 sb=1.4e-07 sca=13.3978 scb=0.0114602 scc=0.001037 fw=4.8e-07 $X=4250 $Y=7900 $dt=1
M13 36 12 VDD VDD g45p1svt w=4.8e-07 l=4.5e-08 ad=6.72e-14 as=6.72e-14 pd=1.24e-06 ps=1.24e-06 sa=1.4e-07 sb=1.4e-07 sca=13.8415 scb=0.0117975 scc=0.0011174 fw=4.8e-07 $X=5440 $Y=7890 $dt=1
.ends faabs

* +++++++++++++++++++++++++++++++++++++++++++++++++++++++++ *
* Sub cell: AND                                             *
* +++++++++++++++++++++++++++++++++++++++++++++++++++++++++ *
.subckt AND VDD GND B A Y 6
*.DEVICECLIMB
** N=7 EP=6 FDC=4
X25 GND Y 6 nmos1v_CDNS_9 $T=420 1020 0 0 $X=0 $Y=820
M0 7 A GND GND g45n1svt w=2.4e-07 l=4.5e-08 ad=3.36e-14 as=3.36e-14 pd=7.6e-07 ps=7.6e-07 sa=1.4e-07 sb=1.4e-07 sca=3.52678 scb=0.000111658 scc=3.66286e-09 fw=2.4e-07 $X=-2110 $Y=920 $dt=0
M1 6 B 7 GND g45n1svt w=2.4e-07 l=4.5e-08 ad=3.36e-14 as=3.36e-14 pd=7.6e-07 ps=7.6e-07 sa=1.4e-07 sb=1.4e-07 sca=3.52678 scb=0.000111658 scc=3.66286e-09 fw=2.4e-07 $X=-830 $Y=920 $dt=0
M2 6 B VDD VDD g45p1svt w=2.4e-07 l=4.5e-08 ad=3.36e-14 as=3.36e-14 pd=7.6e-07 ps=7.6e-07 sa=1.4e-07 sb=1.4e-07 sca=12.8329 scb=0.0117498 scc=0.000390557 fw=2.4e-07 $X=-830 $Y=2770 $dt=1
.ends AND

* +++++++++++++++++++++++++++++++++++++++++++++++++++++++++ *
* Sub cell: Half_Adder                                      *
* +++++++++++++++++++++++++++++++++++++++++++++++++++++++++ *
.subckt Half_Adder B A GND VDD SUM COUT 7 11
*.DEVICECLIMB
** N=13 EP=8 FDC=15
X73 GND 7 A nmos1v_CDNS_9 $T=-2150 3980 0 0 $X=-2570 $Y=3780
X74 GND 8 B nmos1v_CDNS_9 $T=1510 3980 0 0 $X=1090 $Y=3780
X75 GND COUT 8 nmos1v_CDNS_9 $T=3050 3980 0 0 $X=2630 $Y=3780
X76 GND COUT 7 nmos1v_CDNS_9 $T=4390 3980 0 0 $X=3970 $Y=3780
M0 12 8 GND GND g45n1svt w=2.4e-07 l=4.5e-08 ad=3.36e-14 as=3.36e-14 pd=7.6e-07 ps=7.6e-07 sa=1.4e-07 sb=1.4e-07 sca=3.52678 scb=0.000111658 scc=3.66286e-09 fw=2.4e-07 $X=-2160 $Y=-2930 $dt=0
M1 SUM 7 12 GND g45n1svt w=2.4e-07 l=4.5e-08 ad=3.36e-14 as=3.36e-14 pd=7.6e-07 ps=7.6e-07 sa=1.4e-07 sb=1.4e-07 sca=3.52678 scb=0.000111658 scc=3.66286e-09 fw=2.4e-07 $X=-740 $Y=-2930 $dt=0
M2 13 B GND GND g45n1svt w=2.4e-07 l=4.5e-08 ad=3.36e-14 as=3.36e-14 pd=7.6e-07 ps=7.6e-07 sa=1.4e-07 sb=1.4e-07 sca=3.52678 scb=0.000111658 scc=3.66286e-09 fw=2.4e-07 $X=640 $Y=-2930 $dt=0
M3 SUM A 13 GND g45n1svt w=2.4e-07 l=4.5e-08 ad=3.36e-14 as=3.36e-14 pd=7.6e-07 ps=7.6e-07 sa=1.4e-07 sb=1.4e-07 sca=3.52678 scb=0.000111658 scc=3.66286e-09 fw=2.4e-07 $X=2010 $Y=-2930 $dt=0
M4 9 B VDD VDD g45p1svt w=4.8e-07 l=4.5e-08 ad=6.72e-14 as=6.72e-14 pd=1.24e-06 ps=1.24e-06 sa=1.4e-07 sb=1.4e-07 sca=7.67703 scb=0.00492794 scc=0.000127123 fw=4.8e-07 $X=-2160 $Y=-450 $dt=1
M5 7 A VDD VDD g45p1svt w=2.4e-07 l=4.5e-08 ad=3.36e-14 as=3.36e-14 pd=7.6e-07 ps=7.6e-07 sa=1.4e-07 sb=1.4e-07 sca=6.19868 scb=0.00224643 scc=1.06334e-05 fw=2.4e-07 $X=-2150 $Y=1560 $dt=1
M6 SUM 7 9 VDD g45p1svt w=4.8e-07 l=4.5e-08 ad=6.72e-14 as=6.72e-14 pd=1.24e-06 ps=1.24e-06 sa=1.4e-07 sb=1.4e-07 sca=7.2888 scb=0.00480939 scc=0.000127096 fw=4.8e-07 $X=-740 $Y=-450 $dt=1
M7 10 8 VDD VDD g45p1svt w=4.8e-07 l=4.5e-08 ad=6.72e-14 as=6.72e-14 pd=1.24e-06 ps=1.24e-06 sa=1.4e-07 sb=1.4e-07 sca=7.2888 scb=0.00480939 scc=0.000127096 fw=4.8e-07 $X=640 $Y=-450 $dt=1
M8 8 B VDD VDD g45p1svt w=2.4e-07 l=4.5e-08 ad=3.36e-14 as=3.36e-14 pd=7.6e-07 ps=7.6e-07 sa=1.4e-07 sb=1.4e-07 sca=5.82592 scb=0.00213462 scc=1.06087e-05 fw=2.4e-07 $X=1510 $Y=1560 $dt=1
M9 SUM A 10 VDD g45p1svt w=4.8e-07 l=4.5e-08 ad=6.72e-14 as=6.72e-14 pd=1.24e-06 ps=1.24e-06 sa=1.4e-07 sb=1.4e-07 sca=7.2888 scb=0.00480939 scc=0.000127096 fw=4.8e-07 $X=2010 $Y=-450 $dt=1
M10 11 8 VDD VDD g45p1svt w=4.8e-07 l=4.5e-08 ad=6.72e-14 as=6.72e-14 pd=1.24e-06 ps=1.24e-06 sa=1.4e-07 sb=1.4e-07 sca=7.78706 scb=0.00554847 scc=0.000178111 fw=4.8e-07 $X=3050 $Y=1480 $dt=1
.ends Half_Adder

* +++++++++++++++++++++++++++++++++++++++++++++++++++++++++ *
* Sub cell: Multiplier                                      *
* +++++++++++++++++++++++++++++++++++++++++++++++++++++++++ *
.subckt Multiplier A0 A1 A2 A3 B0 B1 B2 B3 P0 GND
+ VDD P3 P1 P2 P4 P5 P6 P7
** N=268 EP=18 FDC=472
X225 VDD GND 19 A0 B3 NAND $T=14090 -32130 0 0 $X=11770 $Y=-33370
X226 VDD GND 26 A1 B3 NAND $T=23370 -32130 0 0 $X=21050 $Y=-33370
X227 VDD GND 35 A2 B3 NAND $T=38270 -32130 0 0 $X=35950 $Y=-33370
X228 VDD GND 40 A3 B0 NAND $T=44420 22640 0 0 $X=42100 $Y=21400
X229 VDD GND 47 A3 B2 NAND $T=47700 -8030 0 0 $X=45380 $Y=-9270
X230 VDD GND 48 A3 B1 NAND $T=47700 16300 0 0 $X=45380 $Y=15060
X231 26 29 VDD GND 25 P4 32 85 81 84
+ 80 82 238 241 Full_Adder $T=29840 -46530 0 0 $X=19850 $Y=-47350
X232 27 30 VDD GND 50 20 33 78 74 77
+ 73 75 234 237 Full_Adder $T=29840 -22560 0 0 $X=19850 $Y=-23380
X233 28 31 VDD GND 51 23 34 71 67 70
+ 66 68 230 233 Full_Adder $T=29840 1770 0 0 $X=19850 $Y=950
X234 35 38 VDD GND 32 P5 41 109 105 108
+ 104 106 250 253 Full_Adder $T=44750 -46530 0 0 $X=34760 $Y=-47350
X235 36 39 VDD GND 33 29 42 102 98 101
+ 97 99 246 249 Full_Adder $T=44750 -22560 0 0 $X=34760 $Y=-23380
X236 37 40 VDD GND 34 30 43 95 91 94
+ 90 92 242 245 Full_Adder $T=44750 1770 0 0 $X=34760 $Y=950
X237 44 46 VDD GND 41 P6 49 133 129 132
+ 128 130 262 265 Full_Adder $T=59000 -46500 0 0 $X=49010 $Y=-47320
X238 45 47 VDD GND 42 38 46 126 122 125
+ 121 123 258 261 Full_Adder $T=59000 -22530 0 0 $X=49010 $Y=-23350
X239 VDD 48 VDD GND 43 39 45 119 115 118
+ 114 116 254 257 Full_Adder $T=59000 1800 0 0 $X=49010 $Y=980
X240 19 20 GND VDD P3 25 61 223 Half_Adder $T=12680 -39880 0 0 $X=8840 $Y=-43630
X241 21 23 GND VDD P2 50 59 229 Half_Adder $T=14110 -22730 0 0 $X=10270 $Y=-26480
X242 22 24 GND VDD P1 51 57 226 Half_Adder $T=14110 1600 0 0 $X=10270 $Y=-2150
X243 VDD 49 GND VDD P7 52 112 268 Half_Adder $T=55780 -29780 0 0 $X=51940 $Y=-33530
X244 VDD GND A0 B0 P0 55 AND $T=11720 21260 0 0 $X=8680 $Y=21410
X245 VDD GND A0 B2 21 54 AND $T=13470 -9180 0 0 $X=10430 $Y=-9030
X246 VDD GND A0 B1 22 53 AND $T=13470 15150 0 0 $X=10430 $Y=15300
X247 VDD GND A1 B0 24 62 AND $T=18650 21260 0 0 $X=15610 $Y=21410
X248 VDD GND A1 B2 27 64 AND $T=23310 -9180 0 0 $X=20270 $Y=-9030
X249 VDD GND A1 B1 28 63 AND $T=23310 15150 0 0 $X=20270 $Y=15300
X250 VDD GND A2 B0 31 86 AND $T=28490 21260 0 0 $X=25450 $Y=21410
X251 VDD GND A2 B2 36 88 AND $T=38240 -9180 0 0 $X=35200 $Y=-9030
X252 VDD GND A2 B1 37 87 AND $T=38240 15150 0 0 $X=35200 $Y=15300
X253 VDD GND A3 B3 44 110 AND $T=45540 -33520 0 0 $X=42500 $Y=-33370
M0 55 B0 VDD VDD g45p1svt w=2.4e-07 l=4.5e-08 ad=3.36e-14 as=3.36e-14 pd=7.6e-07 ps=7.6e-07 sa=1.4e-07 sb=1.4e-07 sca=16.0927 scb=0.0154531 scc=0.000419743 fw=2.4e-07 $X=9610 $Y=24030 $dt=1
M1 54 B2 VDD VDD g45p1svt w=2.4e-07 l=4.5e-08 ad=3.36e-14 as=3.36e-14 pd=7.6e-07 ps=7.6e-07 sa=1.4e-07 sb=1.4e-07 sca=16.0927 scb=0.0154531 scc=0.000419743 fw=2.4e-07 $X=11360 $Y=-6410 $dt=1
M2 53 B1 VDD VDD g45p1svt w=2.4e-07 l=4.5e-08 ad=3.36e-14 as=3.36e-14 pd=7.6e-07 ps=7.6e-07 sa=1.4e-07 sb=1.4e-07 sca=16.0927 scb=0.0154531 scc=0.000419743 fw=2.4e-07 $X=11360 $Y=17920 $dt=1
M3 P0 55 VDD VDD g45p1svt w=2.4e-07 l=4.5e-08 ad=3.36e-14 as=3.36e-14 pd=7.6e-07 ps=7.6e-07 sa=1.4e-07 sb=1.4e-07 sca=15.9246 scb=0.0151668 scc=0.000414946 fw=2.4e-07 $X=12140 $Y=24030 $dt=1
M4 19 B3 VDD VDD g45p1svt w=2.4e-07 l=4.5e-08 ad=3.36e-14 as=3.36e-14 pd=7.6e-07 ps=7.6e-07 sa=1.4e-07 sb=1.4e-07 sca=27.6029 scb=0.0286946 scc=0.00220115 fw=2.4e-07 $X=12510 $Y=-30750 $dt=1
M5 19 A0 VDD VDD g45p1svt w=2.4e-07 l=4.5e-08 ad=3.36e-14 as=3.36e-14 pd=7.6e-07 ps=7.6e-07 sa=1.4e-07 sb=1.4e-07 sca=30.3216 scb=0.0333085 scc=0.0025237 fw=2.4e-07 $X=13760 $Y=-30750 $dt=1
M6 21 54 VDD VDD g45p1svt w=2.4e-07 l=4.5e-08 ad=3.36e-14 as=3.36e-14 pd=7.6e-07 ps=7.6e-07 sa=1.4e-07 sb=1.4e-07 sca=15.9246 scb=0.0151668 scc=0.000414946 fw=2.4e-07 $X=13890 $Y=-6410 $dt=1
M7 22 53 VDD VDD g45p1svt w=2.4e-07 l=4.5e-08 ad=3.36e-14 as=3.36e-14 pd=7.6e-07 ps=7.6e-07 sa=1.4e-07 sb=1.4e-07 sca=15.9246 scb=0.0151668 scc=0.000414946 fw=2.4e-07 $X=13890 $Y=17920 $dt=1
M8 62 B0 VDD VDD g45p1svt w=2.4e-07 l=4.5e-08 ad=3.36e-14 as=3.36e-14 pd=7.6e-07 ps=7.6e-07 sa=1.4e-07 sb=1.4e-07 sca=16.0927 scb=0.0154531 scc=0.000419743 fw=2.4e-07 $X=16540 $Y=24030 $dt=1
M9 25 61 223 VDD g45p1svt w=4.8e-07 l=4.5e-08 ad=6.72e-14 as=6.72e-14 pd=1.24e-06 ps=1.24e-06 sa=1.4e-07 sb=1.4e-07 sca=7.78706 scb=0.00554847 scc=0.000178111 fw=4.8e-07 $X=17070 $Y=-38400 $dt=1
M10 50 59 229 VDD g45p1svt w=4.8e-07 l=4.5e-08 ad=6.72e-14 as=6.72e-14 pd=1.24e-06 ps=1.24e-06 sa=1.4e-07 sb=1.4e-07 sca=7.78706 scb=0.00554847 scc=0.000178111 fw=4.8e-07 $X=18500 $Y=-21250 $dt=1
M11 51 57 226 VDD g45p1svt w=4.8e-07 l=4.5e-08 ad=6.72e-14 as=6.72e-14 pd=1.24e-06 ps=1.24e-06 sa=1.4e-07 sb=1.4e-07 sca=7.78706 scb=0.00554847 scc=0.000178111 fw=4.8e-07 $X=18500 $Y=3080 $dt=1
M12 24 62 VDD VDD g45p1svt w=2.4e-07 l=4.5e-08 ad=3.36e-14 as=3.36e-14 pd=7.6e-07 ps=7.6e-07 sa=1.4e-07 sb=1.4e-07 sca=15.9246 scb=0.0151668 scc=0.000414946 fw=2.4e-07 $X=19070 $Y=24030 $dt=1
M13 64 B2 VDD VDD g45p1svt w=2.4e-07 l=4.5e-08 ad=3.36e-14 as=3.36e-14 pd=7.6e-07 ps=7.6e-07 sa=1.4e-07 sb=1.4e-07 sca=16.0927 scb=0.0154531 scc=0.000419743 fw=2.4e-07 $X=21200 $Y=-6410 $dt=1
M14 63 B1 VDD VDD g45p1svt w=2.4e-07 l=4.5e-08 ad=3.36e-14 as=3.36e-14 pd=7.6e-07 ps=7.6e-07 sa=1.4e-07 sb=1.4e-07 sca=16.0927 scb=0.0154531 scc=0.000419743 fw=2.4e-07 $X=21200 $Y=17920 $dt=1
M15 85 26 VDD VDD g45p1svt w=2.4e-07 l=4.5e-08 ad=3.36e-14 as=3.36e-14 pd=7.6e-07 ps=7.6e-07 sa=1.4e-07 sb=1.4e-07 sca=22.1446 scb=0.0211749 scc=0.0017623 fw=2.4e-07 $X=21520 $Y=-44730 $dt=1
M16 78 27 VDD VDD g45p1svt w=2.4e-07 l=4.5e-08 ad=3.36e-14 as=3.36e-14 pd=7.6e-07 ps=7.6e-07 sa=1.4e-07 sb=1.4e-07 sca=20.4324 scb=0.0198648 scc=0.00175929 fw=2.4e-07 $X=21520 $Y=-20760 $dt=1
M17 71 28 VDD VDD g45p1svt w=2.4e-07 l=4.5e-08 ad=3.36e-14 as=3.36e-14 pd=7.6e-07 ps=7.6e-07 sa=1.4e-07 sb=1.4e-07 sca=20.4324 scb=0.0198648 scc=0.00175929 fw=2.4e-07 $X=21520 $Y=3570 $dt=1
M18 238 26 VDD VDD g45p1svt w=4.8e-07 l=4.5e-08 ad=6.72e-14 as=6.72e-14 pd=1.24e-06 ps=1.24e-06 sa=1.4e-07 sb=1.4e-07 sca=9.47395 scb=0.00759651 scc=0.000374483 fw=4.8e-07 $X=21650 $Y=-39250 $dt=1
M19 234 27 VDD VDD g45p1svt w=4.8e-07 l=4.5e-08 ad=6.72e-14 as=6.72e-14 pd=1.24e-06 ps=1.24e-06 sa=1.4e-07 sb=1.4e-07 sca=9.69279 scb=0.0076507 scc=0.000374491 fw=4.8e-07 $X=21650 $Y=-15280 $dt=1
M20 230 28 VDD VDD g45p1svt w=4.8e-07 l=4.5e-08 ad=6.72e-14 as=6.72e-14 pd=1.24e-06 ps=1.24e-06 sa=1.4e-07 sb=1.4e-07 sca=9.69279 scb=0.0076507 scc=0.000374491 fw=4.8e-07 $X=21650 $Y=9050 $dt=1
M21 80 29 VDD VDD g45p1svt w=2.4e-07 l=4.5e-08 ad=3.36e-14 as=3.36e-14 pd=7.6e-07 ps=7.6e-07 sa=1.4e-07 sb=1.4e-07 sca=34.1422 scb=0.0251568 scc=0.00441949 fw=2.4e-07 $X=21660 $Y=-37240 $dt=1
M22 73 30 VDD VDD g45p1svt w=2.4e-07 l=4.5e-08 ad=3.36e-14 as=3.36e-14 pd=7.6e-07 ps=7.6e-07 sa=1.4e-07 sb=1.4e-07 sca=34.3484 scb=0.025207 scc=0.0044195 fw=2.4e-07 $X=21660 $Y=-13270 $dt=1
M23 66 31 VDD VDD g45p1svt w=2.4e-07 l=4.5e-08 ad=3.36e-14 as=3.36e-14 pd=7.6e-07 ps=7.6e-07 sa=1.4e-07 sb=1.4e-07 sca=34.3484 scb=0.025207 scc=0.0044195 fw=2.4e-07 $X=21660 $Y=11060 $dt=1
M24 26 B3 VDD VDD g45p1svt w=2.4e-07 l=4.5e-08 ad=3.36e-14 as=3.36e-14 pd=7.6e-07 ps=7.6e-07 sa=1.4e-07 sb=1.4e-07 sca=27.6029 scb=0.0286946 scc=0.00220115 fw=2.4e-07 $X=21790 $Y=-30750 $dt=1
M25 85 29 VDD VDD g45p1svt w=2.4e-07 l=4.5e-08 ad=3.36e-14 as=3.36e-14 pd=7.6e-07 ps=7.6e-07 sa=1.4e-07 sb=1.4e-07 sca=20.4324 scb=0.0198648 scc=0.00175929 fw=2.4e-07 $X=22770 $Y=-44730 $dt=1
M26 78 30 VDD VDD g45p1svt w=2.4e-07 l=4.5e-08 ad=3.36e-14 as=3.36e-14 pd=7.6e-07 ps=7.6e-07 sa=1.4e-07 sb=1.4e-07 sca=20.4324 scb=0.0198648 scc=0.00175929 fw=2.4e-07 $X=22770 $Y=-20760 $dt=1
M27 71 31 VDD VDD g45p1svt w=2.4e-07 l=4.5e-08 ad=3.36e-14 as=3.36e-14 pd=7.6e-07 ps=7.6e-07 sa=1.4e-07 sb=1.4e-07 sca=20.4324 scb=0.0198648 scc=0.00175929 fw=2.4e-07 $X=22770 $Y=3570 $dt=1
M28 26 A1 VDD VDD g45p1svt w=2.4e-07 l=4.5e-08 ad=3.36e-14 as=3.36e-14 pd=7.6e-07 ps=7.6e-07 sa=1.4e-07 sb=1.4e-07 sca=30.3216 scb=0.0333085 scc=0.0025237 fw=2.4e-07 $X=23040 $Y=-30750 $dt=1
M29 27 64 VDD VDD g45p1svt w=2.4e-07 l=4.5e-08 ad=3.36e-14 as=3.36e-14 pd=7.6e-07 ps=7.6e-07 sa=1.4e-07 sb=1.4e-07 sca=15.9246 scb=0.0151668 scc=0.000414946 fw=2.4e-07 $X=23730 $Y=-6410 $dt=1
M30 28 63 VDD VDD g45p1svt w=2.4e-07 l=4.5e-08 ad=3.36e-14 as=3.36e-14 pd=7.6e-07 ps=7.6e-07 sa=1.4e-07 sb=1.4e-07 sca=15.9246 scb=0.0151668 scc=0.000414946 fw=2.4e-07 $X=23730 $Y=17920 $dt=1
M31 86 B0 VDD VDD g45p1svt w=2.4e-07 l=4.5e-08 ad=3.36e-14 as=3.36e-14 pd=7.6e-07 ps=7.6e-07 sa=1.4e-07 sb=1.4e-07 sca=16.0927 scb=0.0154531 scc=0.000419743 fw=2.4e-07 $X=26380 $Y=24030 $dt=1
M32 84 81 VDD VDD g45p1svt w=2.4e-07 l=4.5e-08 ad=3.36e-14 as=3.36e-14 pd=7.6e-07 ps=7.6e-07 sa=1.4e-07 sb=1.4e-07 sca=20.4324 scb=0.0198648 scc=0.00175929 fw=2.4e-07 $X=28140 $Y=-44730 $dt=1
M33 77 74 VDD VDD g45p1svt w=2.4e-07 l=4.5e-08 ad=3.36e-14 as=3.36e-14 pd=7.6e-07 ps=7.6e-07 sa=1.4e-07 sb=1.4e-07 sca=20.4324 scb=0.0198648 scc=0.00175929 fw=2.4e-07 $X=28140 $Y=-20760 $dt=1
M34 70 67 VDD VDD g45p1svt w=2.4e-07 l=4.5e-08 ad=3.36e-14 as=3.36e-14 pd=7.6e-07 ps=7.6e-07 sa=1.4e-07 sb=1.4e-07 sca=20.4324 scb=0.0198648 scc=0.00175929 fw=2.4e-07 $X=28140 $Y=3570 $dt=1
M35 31 86 VDD VDD g45p1svt w=2.4e-07 l=4.5e-08 ad=3.36e-14 as=3.36e-14 pd=7.6e-07 ps=7.6e-07 sa=1.4e-07 sb=1.4e-07 sca=15.9246 scb=0.0151668 scc=0.000414946 fw=2.4e-07 $X=28910 $Y=24030 $dt=1
M36 84 25 VDD VDD g45p1svt w=2.4e-07 l=4.5e-08 ad=3.36e-14 as=3.36e-14 pd=7.6e-07 ps=7.6e-07 sa=1.4e-07 sb=1.4e-07 sca=20.4324 scb=0.0198648 scc=0.00175929 fw=2.4e-07 $X=29390 $Y=-44730 $dt=1
M37 77 50 VDD VDD g45p1svt w=2.4e-07 l=4.5e-08 ad=3.36e-14 as=3.36e-14 pd=7.6e-07 ps=7.6e-07 sa=1.4e-07 sb=1.4e-07 sca=20.4324 scb=0.0198648 scc=0.00175929 fw=2.4e-07 $X=29390 $Y=-20760 $dt=1
M38 70 51 VDD VDD g45p1svt w=2.4e-07 l=4.5e-08 ad=3.36e-14 as=3.36e-14 pd=7.6e-07 ps=7.6e-07 sa=1.4e-07 sb=1.4e-07 sca=20.4324 scb=0.0198648 scc=0.00175929 fw=2.4e-07 $X=29390 $Y=3570 $dt=1
M39 32 84 VDD VDD g45p1svt w=2.4e-07 l=4.5e-08 ad=3.36e-14 as=3.36e-14 pd=7.6e-07 ps=7.6e-07 sa=1.4e-07 sb=1.4e-07 sca=20.4324 scb=0.0198648 scc=0.00175929 fw=2.4e-07 $X=31350 $Y=-44730 $dt=1
M40 33 77 VDD VDD g45p1svt w=2.4e-07 l=4.5e-08 ad=3.36e-14 as=3.36e-14 pd=7.6e-07 ps=7.6e-07 sa=1.4e-07 sb=1.4e-07 sca=20.4324 scb=0.0198648 scc=0.00175929 fw=2.4e-07 $X=31350 $Y=-20760 $dt=1
M41 34 70 VDD VDD g45p1svt w=2.4e-07 l=4.5e-08 ad=3.36e-14 as=3.36e-14 pd=7.6e-07 ps=7.6e-07 sa=1.4e-07 sb=1.4e-07 sca=20.4324 scb=0.0198648 scc=0.00175929 fw=2.4e-07 $X=31350 $Y=3570 $dt=1
M42 82 25 VDD VDD g45p1svt w=2.4e-07 l=4.5e-08 ad=3.36e-14 as=3.36e-14 pd=7.6e-07 ps=7.6e-07 sa=1.4e-07 sb=1.4e-07 sca=34.1422 scb=0.0251568 scc=0.00441949 fw=2.4e-07 $X=32130 $Y=-37240 $dt=1
M43 75 50 VDD VDD g45p1svt w=2.4e-07 l=4.5e-08 ad=3.36e-14 as=3.36e-14 pd=7.6e-07 ps=7.6e-07 sa=1.4e-07 sb=1.4e-07 sca=34.1422 scb=0.0251568 scc=0.00441949 fw=2.4e-07 $X=32130 $Y=-13270 $dt=1
M44 68 51 VDD VDD g45p1svt w=2.4e-07 l=4.5e-08 ad=3.36e-14 as=3.36e-14 pd=7.6e-07 ps=7.6e-07 sa=1.4e-07 sb=1.4e-07 sca=34.1422 scb=0.0251568 scc=0.00441949 fw=2.4e-07 $X=32130 $Y=11060 $dt=1
M45 32 85 VDD VDD g45p1svt w=2.4e-07 l=4.5e-08 ad=3.36e-14 as=3.36e-14 pd=7.6e-07 ps=7.6e-07 sa=1.4e-07 sb=1.4e-07 sca=20.4324 scb=0.0198648 scc=0.00175929 fw=2.4e-07 $X=32600 $Y=-44730 $dt=1
M46 33 78 VDD VDD g45p1svt w=2.4e-07 l=4.5e-08 ad=3.36e-14 as=3.36e-14 pd=7.6e-07 ps=7.6e-07 sa=1.4e-07 sb=1.4e-07 sca=20.4324 scb=0.0198648 scc=0.00175929 fw=2.4e-07 $X=32600 $Y=-20760 $dt=1
M47 34 71 VDD VDD g45p1svt w=2.4e-07 l=4.5e-08 ad=3.36e-14 as=3.36e-14 pd=7.6e-07 ps=7.6e-07 sa=1.4e-07 sb=1.4e-07 sca=20.4324 scb=0.0198648 scc=0.00175929 fw=2.4e-07 $X=32600 $Y=3570 $dt=1
M48 P4 81 241 VDD g45p1svt w=4.8e-07 l=4.5e-08 ad=6.72e-14 as=6.72e-14 pd=1.24e-06 ps=1.24e-06 sa=1.4e-07 sb=1.4e-07 sca=9.47395 scb=0.00759651 scc=0.000374483 fw=4.8e-07 $X=32630 $Y=-39250 $dt=1
M49 20 74 237 VDD g45p1svt w=4.8e-07 l=4.5e-08 ad=6.72e-14 as=6.72e-14 pd=1.24e-06 ps=1.24e-06 sa=1.4e-07 sb=1.4e-07 sca=9.47395 scb=0.00759651 scc=0.000374483 fw=4.8e-07 $X=32630 $Y=-15280 $dt=1
M50 23 67 233 VDD g45p1svt w=4.8e-07 l=4.5e-08 ad=6.72e-14 as=6.72e-14 pd=1.24e-06 ps=1.24e-06 sa=1.4e-07 sb=1.4e-07 sca=9.47395 scb=0.00759651 scc=0.000374483 fw=4.8e-07 $X=32630 $Y=9050 $dt=1
M51 88 B2 VDD VDD g45p1svt w=2.4e-07 l=4.5e-08 ad=3.36e-14 as=3.36e-14 pd=7.6e-07 ps=7.6e-07 sa=1.4e-07 sb=1.4e-07 sca=16.0927 scb=0.0154531 scc=0.000419743 fw=2.4e-07 $X=36130 $Y=-6410 $dt=1
M52 87 B1 VDD VDD g45p1svt w=2.4e-07 l=4.5e-08 ad=3.36e-14 as=3.36e-14 pd=7.6e-07 ps=7.6e-07 sa=1.4e-07 sb=1.4e-07 sca=16.0927 scb=0.0154531 scc=0.000419743 fw=2.4e-07 $X=36130 $Y=17920 $dt=1
M53 109 35 VDD VDD g45p1svt w=2.4e-07 l=4.5e-08 ad=3.36e-14 as=3.36e-14 pd=7.6e-07 ps=7.6e-07 sa=1.4e-07 sb=1.4e-07 sca=20.4324 scb=0.0198648 scc=0.00175929 fw=2.4e-07 $X=36430 $Y=-44730 $dt=1
M54 102 36 VDD VDD g45p1svt w=2.4e-07 l=4.5e-08 ad=3.36e-14 as=3.36e-14 pd=7.6e-07 ps=7.6e-07 sa=1.4e-07 sb=1.4e-07 sca=20.4324 scb=0.0198648 scc=0.00175929 fw=2.4e-07 $X=36430 $Y=-20760 $dt=1
M55 95 37 VDD VDD g45p1svt w=2.4e-07 l=4.5e-08 ad=3.36e-14 as=3.36e-14 pd=7.6e-07 ps=7.6e-07 sa=1.4e-07 sb=1.4e-07 sca=20.4324 scb=0.0198648 scc=0.00175929 fw=2.4e-07 $X=36430 $Y=3570 $dt=1
M56 250 35 VDD VDD g45p1svt w=4.8e-07 l=4.5e-08 ad=6.72e-14 as=6.72e-14 pd=1.24e-06 ps=1.24e-06 sa=1.4e-07 sb=1.4e-07 sca=9.47395 scb=0.00759651 scc=0.000374483 fw=4.8e-07 $X=36560 $Y=-39250 $dt=1
M57 246 36 VDD VDD g45p1svt w=4.8e-07 l=4.5e-08 ad=6.72e-14 as=6.72e-14 pd=1.24e-06 ps=1.24e-06 sa=1.4e-07 sb=1.4e-07 sca=9.47395 scb=0.00759651 scc=0.000374483 fw=4.8e-07 $X=36560 $Y=-15280 $dt=1
M58 242 37 VDD VDD g45p1svt w=4.8e-07 l=4.5e-08 ad=6.72e-14 as=6.72e-14 pd=1.24e-06 ps=1.24e-06 sa=1.4e-07 sb=1.4e-07 sca=9.47395 scb=0.00759651 scc=0.000374483 fw=4.8e-07 $X=36560 $Y=9050 $dt=1
M59 104 38 VDD VDD g45p1svt w=2.4e-07 l=4.5e-08 ad=3.36e-14 as=3.36e-14 pd=7.6e-07 ps=7.6e-07 sa=1.4e-07 sb=1.4e-07 sca=34.1422 scb=0.0251568 scc=0.00441949 fw=2.4e-07 $X=36570 $Y=-37240 $dt=1
M60 97 39 VDD VDD g45p1svt w=2.4e-07 l=4.5e-08 ad=3.36e-14 as=3.36e-14 pd=7.6e-07 ps=7.6e-07 sa=1.4e-07 sb=1.4e-07 sca=34.1422 scb=0.0251568 scc=0.00441949 fw=2.4e-07 $X=36570 $Y=-13270 $dt=1
M61 90 40 VDD VDD g45p1svt w=2.4e-07 l=4.5e-08 ad=3.36e-14 as=3.36e-14 pd=7.6e-07 ps=7.6e-07 sa=1.4e-07 sb=1.4e-07 sca=34.1422 scb=0.0251568 scc=0.00441949 fw=2.4e-07 $X=36570 $Y=11060 $dt=1
M62 35 B3 VDD VDD g45p1svt w=2.4e-07 l=4.5e-08 ad=3.36e-14 as=3.36e-14 pd=7.6e-07 ps=7.6e-07 sa=1.4e-07 sb=1.4e-07 sca=27.6029 scb=0.0286946 scc=0.00220115 fw=2.4e-07 $X=36690 $Y=-30750 $dt=1
M63 109 38 VDD VDD g45p1svt w=2.4e-07 l=4.5e-08 ad=3.36e-14 as=3.36e-14 pd=7.6e-07 ps=7.6e-07 sa=1.4e-07 sb=1.4e-07 sca=20.4324 scb=0.0198648 scc=0.00175929 fw=2.4e-07 $X=37680 $Y=-44730 $dt=1
M64 102 39 VDD VDD g45p1svt w=2.4e-07 l=4.5e-08 ad=3.36e-14 as=3.36e-14 pd=7.6e-07 ps=7.6e-07 sa=1.4e-07 sb=1.4e-07 sca=20.4324 scb=0.0198648 scc=0.00175929 fw=2.4e-07 $X=37680 $Y=-20760 $dt=1
M65 95 40 VDD VDD g45p1svt w=2.4e-07 l=4.5e-08 ad=3.36e-14 as=3.36e-14 pd=7.6e-07 ps=7.6e-07 sa=1.4e-07 sb=1.4e-07 sca=20.4324 scb=0.0198648 scc=0.00175929 fw=2.4e-07 $X=37680 $Y=3570 $dt=1
M66 35 A2 VDD VDD g45p1svt w=2.4e-07 l=4.5e-08 ad=3.36e-14 as=3.36e-14 pd=7.6e-07 ps=7.6e-07 sa=1.4e-07 sb=1.4e-07 sca=30.3216 scb=0.0333085 scc=0.0025237 fw=2.4e-07 $X=37940 $Y=-30750 $dt=1
M67 36 88 VDD VDD g45p1svt w=2.4e-07 l=4.5e-08 ad=3.36e-14 as=3.36e-14 pd=7.6e-07 ps=7.6e-07 sa=1.4e-07 sb=1.4e-07 sca=15.9246 scb=0.0151668 scc=0.000414946 fw=2.4e-07 $X=38660 $Y=-6410 $dt=1
M68 37 87 VDD VDD g45p1svt w=2.4e-07 l=4.5e-08 ad=3.36e-14 as=3.36e-14 pd=7.6e-07 ps=7.6e-07 sa=1.4e-07 sb=1.4e-07 sca=15.9246 scb=0.0151668 scc=0.000414946 fw=2.4e-07 $X=38660 $Y=17920 $dt=1
M69 40 B0 VDD VDD g45p1svt w=2.4e-07 l=4.5e-08 ad=3.36e-14 as=3.36e-14 pd=7.6e-07 ps=7.6e-07 sa=1.4e-07 sb=1.4e-07 sca=27.457 scb=0.0286619 scc=0.00220114 fw=2.4e-07 $X=42840 $Y=24020 $dt=1
M70 108 105 VDD VDD g45p1svt w=2.4e-07 l=4.5e-08 ad=3.36e-14 as=3.36e-14 pd=7.6e-07 ps=7.6e-07 sa=1.4e-07 sb=1.4e-07 sca=20.4324 scb=0.0198648 scc=0.00175929 fw=2.4e-07 $X=43050 $Y=-44730 $dt=1
M71 101 98 VDD VDD g45p1svt w=2.4e-07 l=4.5e-08 ad=3.36e-14 as=3.36e-14 pd=7.6e-07 ps=7.6e-07 sa=1.4e-07 sb=1.4e-07 sca=20.4324 scb=0.0198648 scc=0.00175929 fw=2.4e-07 $X=43050 $Y=-20760 $dt=1
M72 94 91 VDD VDD g45p1svt w=2.4e-07 l=4.5e-08 ad=3.36e-14 as=3.36e-14 pd=7.6e-07 ps=7.6e-07 sa=1.4e-07 sb=1.4e-07 sca=20.4324 scb=0.0198648 scc=0.00175929 fw=2.4e-07 $X=43050 $Y=3570 $dt=1
M73 110 B3 VDD VDD g45p1svt w=2.4e-07 l=4.5e-08 ad=3.36e-14 as=3.36e-14 pd=7.6e-07 ps=7.6e-07 sa=1.4e-07 sb=1.4e-07 sca=16.0927 scb=0.0154531 scc=0.000419743 fw=2.4e-07 $X=43430 $Y=-30750 $dt=1
M74 40 A3 VDD VDD g45p1svt w=2.4e-07 l=4.5e-08 ad=3.36e-14 as=3.36e-14 pd=7.6e-07 ps=7.6e-07 sa=1.4e-07 sb=1.4e-07 sca=21.9108 scb=0.0209201 scc=0.00204429 fw=2.4e-07 $X=44090 $Y=24020 $dt=1
M75 108 32 VDD VDD g45p1svt w=2.4e-07 l=4.5e-08 ad=3.36e-14 as=3.36e-14 pd=7.6e-07 ps=7.6e-07 sa=1.4e-07 sb=1.4e-07 sca=20.4324 scb=0.0198648 scc=0.00175929 fw=2.4e-07 $X=44300 $Y=-44730 $dt=1
M76 101 33 VDD VDD g45p1svt w=2.4e-07 l=4.5e-08 ad=3.36e-14 as=3.36e-14 pd=7.6e-07 ps=7.6e-07 sa=1.4e-07 sb=1.4e-07 sca=20.4324 scb=0.0198648 scc=0.00175929 fw=2.4e-07 $X=44300 $Y=-20760 $dt=1
M77 94 34 VDD VDD g45p1svt w=2.4e-07 l=4.5e-08 ad=3.36e-14 as=3.36e-14 pd=7.6e-07 ps=7.6e-07 sa=1.4e-07 sb=1.4e-07 sca=20.4324 scb=0.0198648 scc=0.00175929 fw=2.4e-07 $X=44300 $Y=3570 $dt=1
M78 44 110 VDD VDD g45p1svt w=2.4e-07 l=4.5e-08 ad=3.36e-14 as=3.36e-14 pd=7.6e-07 ps=7.6e-07 sa=1.4e-07 sb=1.4e-07 sca=15.9246 scb=0.0151668 scc=0.000414946 fw=2.4e-07 $X=45960 $Y=-30750 $dt=1
M79 47 B2 VDD VDD g45p1svt w=2.4e-07 l=4.5e-08 ad=3.36e-14 as=3.36e-14 pd=7.6e-07 ps=7.6e-07 sa=1.4e-07 sb=1.4e-07 sca=27.6029 scb=0.0286946 scc=0.00220115 fw=2.4e-07 $X=46120 $Y=-6650 $dt=1
M80 48 B1 VDD VDD g45p1svt w=2.4e-07 l=4.5e-08 ad=3.36e-14 as=3.36e-14 pd=7.6e-07 ps=7.6e-07 sa=1.4e-07 sb=1.4e-07 sca=27.6029 scb=0.0286946 scc=0.00220115 fw=2.4e-07 $X=46120 $Y=17680 $dt=1
M81 41 108 VDD VDD g45p1svt w=2.4e-07 l=4.5e-08 ad=3.36e-14 as=3.36e-14 pd=7.6e-07 ps=7.6e-07 sa=1.4e-07 sb=1.4e-07 sca=20.4324 scb=0.0198648 scc=0.00175929 fw=2.4e-07 $X=46260 $Y=-44730 $dt=1
M82 42 101 VDD VDD g45p1svt w=2.4e-07 l=4.5e-08 ad=3.36e-14 as=3.36e-14 pd=7.6e-07 ps=7.6e-07 sa=1.4e-07 sb=1.4e-07 sca=20.4324 scb=0.0198648 scc=0.00175929 fw=2.4e-07 $X=46260 $Y=-20760 $dt=1
M83 43 94 VDD VDD g45p1svt w=2.4e-07 l=4.5e-08 ad=3.36e-14 as=3.36e-14 pd=7.6e-07 ps=7.6e-07 sa=1.4e-07 sb=1.4e-07 sca=20.4324 scb=0.0198648 scc=0.00175929 fw=2.4e-07 $X=46260 $Y=3570 $dt=1
M84 106 32 VDD VDD g45p1svt w=2.4e-07 l=4.5e-08 ad=3.36e-14 as=3.36e-14 pd=7.6e-07 ps=7.6e-07 sa=1.4e-07 sb=1.4e-07 sca=34.1422 scb=0.0251568 scc=0.00441949 fw=2.4e-07 $X=47040 $Y=-37240 $dt=1
M85 99 33 VDD VDD g45p1svt w=2.4e-07 l=4.5e-08 ad=3.36e-14 as=3.36e-14 pd=7.6e-07 ps=7.6e-07 sa=1.4e-07 sb=1.4e-07 sca=34.1422 scb=0.0251568 scc=0.00441949 fw=2.4e-07 $X=47040 $Y=-13270 $dt=1
M86 92 34 VDD VDD g45p1svt w=2.4e-07 l=4.5e-08 ad=3.36e-14 as=3.36e-14 pd=7.6e-07 ps=7.6e-07 sa=1.4e-07 sb=1.4e-07 sca=34.1422 scb=0.0251568 scc=0.00441949 fw=2.4e-07 $X=47040 $Y=11060 $dt=1
M87 47 A3 VDD VDD g45p1svt w=2.4e-07 l=4.5e-08 ad=3.36e-14 as=3.36e-14 pd=7.6e-07 ps=7.6e-07 sa=1.4e-07 sb=1.4e-07 sca=30.3216 scb=0.0333085 scc=0.0025237 fw=2.4e-07 $X=47370 $Y=-6650 $dt=1
M88 48 A3 VDD VDD g45p1svt w=2.4e-07 l=4.5e-08 ad=3.36e-14 as=3.36e-14 pd=7.6e-07 ps=7.6e-07 sa=1.4e-07 sb=1.4e-07 sca=30.3216 scb=0.0333085 scc=0.0025237 fw=2.4e-07 $X=47370 $Y=17680 $dt=1
M89 41 109 VDD VDD g45p1svt w=2.4e-07 l=4.5e-08 ad=3.36e-14 as=3.36e-14 pd=7.6e-07 ps=7.6e-07 sa=1.4e-07 sb=1.4e-07 sca=20.4324 scb=0.0198648 scc=0.00175929 fw=2.4e-07 $X=47510 $Y=-44730 $dt=1
M90 42 102 VDD VDD g45p1svt w=2.4e-07 l=4.5e-08 ad=3.36e-14 as=3.36e-14 pd=7.6e-07 ps=7.6e-07 sa=1.4e-07 sb=1.4e-07 sca=20.4324 scb=0.0198648 scc=0.00175929 fw=2.4e-07 $X=47510 $Y=-20760 $dt=1
M91 43 95 VDD VDD g45p1svt w=2.4e-07 l=4.5e-08 ad=3.36e-14 as=3.36e-14 pd=7.6e-07 ps=7.6e-07 sa=1.4e-07 sb=1.4e-07 sca=20.4324 scb=0.0198648 scc=0.00175929 fw=2.4e-07 $X=47510 $Y=3570 $dt=1
M92 P5 105 253 VDD g45p1svt w=4.8e-07 l=4.5e-08 ad=6.72e-14 as=6.72e-14 pd=1.24e-06 ps=1.24e-06 sa=1.4e-07 sb=1.4e-07 sca=9.47395 scb=0.00759651 scc=0.000374483 fw=4.8e-07 $X=47540 $Y=-39250 $dt=1
M93 29 98 249 VDD g45p1svt w=4.8e-07 l=4.5e-08 ad=6.72e-14 as=6.72e-14 pd=1.24e-06 ps=1.24e-06 sa=1.4e-07 sb=1.4e-07 sca=9.47395 scb=0.00759651 scc=0.000374483 fw=4.8e-07 $X=47540 $Y=-15280 $dt=1
M94 30 91 245 VDD g45p1svt w=4.8e-07 l=4.5e-08 ad=6.72e-14 as=6.72e-14 pd=1.24e-06 ps=1.24e-06 sa=1.4e-07 sb=1.4e-07 sca=9.47395 scb=0.00759651 scc=0.000374483 fw=4.8e-07 $X=47540 $Y=9050 $dt=1
M95 133 44 VDD VDD g45p1svt w=2.4e-07 l=4.5e-08 ad=3.36e-14 as=3.36e-14 pd=7.6e-07 ps=7.6e-07 sa=1.4e-07 sb=1.4e-07 sca=20.4324 scb=0.0198648 scc=0.00175929 fw=2.4e-07 $X=50680 $Y=-44700 $dt=1
M96 126 45 VDD VDD g45p1svt w=2.4e-07 l=4.5e-08 ad=3.36e-14 as=3.36e-14 pd=7.6e-07 ps=7.6e-07 sa=1.4e-07 sb=1.4e-07 sca=20.4324 scb=0.0198648 scc=0.00175929 fw=2.4e-07 $X=50680 $Y=-20730 $dt=1
M97 119 VDD VDD VDD g45p1svt w=2.4e-07 l=4.5e-08 ad=3.36e-14 as=3.36e-14 pd=7.6e-07 ps=7.6e-07 sa=1.4e-07 sb=1.4e-07 sca=20.4324 scb=0.0198648 scc=0.00175929 fw=2.4e-07 $X=50680 $Y=3600 $dt=1
M98 262 44 VDD VDD g45p1svt w=4.8e-07 l=4.5e-08 ad=6.72e-14 as=6.72e-14 pd=1.24e-06 ps=1.24e-06 sa=1.4e-07 sb=1.4e-07 sca=9.47395 scb=0.00759651 scc=0.000374483 fw=4.8e-07 $X=50810 $Y=-39220 $dt=1
M99 258 45 VDD VDD g45p1svt w=4.8e-07 l=4.5e-08 ad=6.72e-14 as=6.72e-14 pd=1.24e-06 ps=1.24e-06 sa=1.4e-07 sb=1.4e-07 sca=9.47395 scb=0.00759651 scc=0.000374483 fw=4.8e-07 $X=50810 $Y=-15250 $dt=1
M100 254 VDD VDD VDD g45p1svt w=4.8e-07 l=4.5e-08 ad=6.72e-14 as=6.72e-14 pd=1.24e-06 ps=1.24e-06 sa=1.4e-07 sb=1.4e-07 sca=9.47395 scb=0.00759651 scc=0.000374483 fw=4.8e-07 $X=50810 $Y=9080 $dt=1
M101 128 46 VDD VDD g45p1svt w=2.4e-07 l=4.5e-08 ad=3.36e-14 as=3.36e-14 pd=7.6e-07 ps=7.6e-07 sa=1.4e-07 sb=1.4e-07 sca=34.1422 scb=0.0251568 scc=0.00441949 fw=2.4e-07 $X=50820 $Y=-37210 $dt=1
M102 121 47 VDD VDD g45p1svt w=2.4e-07 l=4.5e-08 ad=3.36e-14 as=3.36e-14 pd=7.6e-07 ps=7.6e-07 sa=1.4e-07 sb=1.4e-07 sca=34.1422 scb=0.0251568 scc=0.00441949 fw=2.4e-07 $X=50820 $Y=-13240 $dt=1
M103 114 48 VDD VDD g45p1svt w=2.4e-07 l=4.5e-08 ad=3.36e-14 as=3.36e-14 pd=7.6e-07 ps=7.6e-07 sa=1.4e-07 sb=1.4e-07 sca=34.1422 scb=0.0251568 scc=0.00441949 fw=2.4e-07 $X=50820 $Y=11090 $dt=1
M104 133 46 VDD VDD g45p1svt w=2.4e-07 l=4.5e-08 ad=3.36e-14 as=3.36e-14 pd=7.6e-07 ps=7.6e-07 sa=1.4e-07 sb=1.4e-07 sca=20.4324 scb=0.0198648 scc=0.00175929 fw=2.4e-07 $X=51930 $Y=-44700 $dt=1
M105 126 47 VDD VDD g45p1svt w=2.4e-07 l=4.5e-08 ad=3.36e-14 as=3.36e-14 pd=7.6e-07 ps=7.6e-07 sa=1.4e-07 sb=1.4e-07 sca=20.4324 scb=0.0198648 scc=0.00175929 fw=2.4e-07 $X=51930 $Y=-20730 $dt=1
M106 119 48 VDD VDD g45p1svt w=2.4e-07 l=4.5e-08 ad=3.36e-14 as=3.36e-14 pd=7.6e-07 ps=7.6e-07 sa=1.4e-07 sb=1.4e-07 sca=20.4324 scb=0.0198648 scc=0.00175929 fw=2.4e-07 $X=51930 $Y=3600 $dt=1
M107 132 129 VDD VDD g45p1svt w=2.4e-07 l=4.5e-08 ad=3.36e-14 as=3.36e-14 pd=7.6e-07 ps=7.6e-07 sa=1.4e-07 sb=1.4e-07 sca=20.4324 scb=0.0198648 scc=0.00175929 fw=2.4e-07 $X=57300 $Y=-44700 $dt=1
M108 125 122 VDD VDD g45p1svt w=2.4e-07 l=4.5e-08 ad=3.36e-14 as=3.36e-14 pd=7.6e-07 ps=7.6e-07 sa=1.4e-07 sb=1.4e-07 sca=20.4324 scb=0.0198648 scc=0.00175929 fw=2.4e-07 $X=57300 $Y=-20730 $dt=1
M109 118 115 VDD VDD g45p1svt w=2.4e-07 l=4.5e-08 ad=3.36e-14 as=3.36e-14 pd=7.6e-07 ps=7.6e-07 sa=1.4e-07 sb=1.4e-07 sca=20.4324 scb=0.0198648 scc=0.00175929 fw=2.4e-07 $X=57300 $Y=3600 $dt=1
M110 132 41 VDD VDD g45p1svt w=2.4e-07 l=4.5e-08 ad=3.36e-14 as=3.36e-14 pd=7.6e-07 ps=7.6e-07 sa=1.4e-07 sb=1.4e-07 sca=20.4324 scb=0.0198648 scc=0.00175929 fw=2.4e-07 $X=58550 $Y=-44700 $dt=1
M111 125 42 VDD VDD g45p1svt w=2.4e-07 l=4.5e-08 ad=3.36e-14 as=3.36e-14 pd=7.6e-07 ps=7.6e-07 sa=1.4e-07 sb=1.4e-07 sca=20.4324 scb=0.0198648 scc=0.00175929 fw=2.4e-07 $X=58550 $Y=-20730 $dt=1
M112 118 43 VDD VDD g45p1svt w=2.4e-07 l=4.5e-08 ad=3.36e-14 as=3.36e-14 pd=7.6e-07 ps=7.6e-07 sa=1.4e-07 sb=1.4e-07 sca=20.4324 scb=0.0198648 scc=0.00175929 fw=2.4e-07 $X=58550 $Y=3600 $dt=1
M113 52 112 268 VDD g45p1svt w=4.8e-07 l=4.5e-08 ad=6.72e-14 as=6.72e-14 pd=1.24e-06 ps=1.24e-06 sa=1.4e-07 sb=1.4e-07 sca=8.67038 scb=0.00597621 scc=0.000178408 fw=4.8e-07 $X=60170 $Y=-28300 $dt=1
M114 49 132 VDD VDD g45p1svt w=2.4e-07 l=4.5e-08 ad=3.36e-14 as=3.36e-14 pd=7.6e-07 ps=7.6e-07 sa=1.4e-07 sb=1.4e-07 sca=20.4324 scb=0.0198648 scc=0.00175929 fw=2.4e-07 $X=60510 $Y=-44700 $dt=1
M115 46 125 VDD VDD g45p1svt w=2.4e-07 l=4.5e-08 ad=3.36e-14 as=3.36e-14 pd=7.6e-07 ps=7.6e-07 sa=1.4e-07 sb=1.4e-07 sca=20.4324 scb=0.0198648 scc=0.00175929 fw=2.4e-07 $X=60510 $Y=-20730 $dt=1
M116 45 118 VDD VDD g45p1svt w=2.4e-07 l=4.5e-08 ad=3.36e-14 as=3.36e-14 pd=7.6e-07 ps=7.6e-07 sa=1.4e-07 sb=1.4e-07 sca=20.4324 scb=0.0198648 scc=0.00175929 fw=2.4e-07 $X=60510 $Y=3600 $dt=1
M117 130 41 VDD VDD g45p1svt w=2.4e-07 l=4.5e-08 ad=3.36e-14 as=3.36e-14 pd=7.6e-07 ps=7.6e-07 sa=1.4e-07 sb=1.4e-07 sca=35.0507 scb=0.0256051 scc=0.00441982 fw=2.4e-07 $X=61290 $Y=-37210 $dt=1
M118 123 42 VDD VDD g45p1svt w=2.4e-07 l=4.5e-08 ad=3.36e-14 as=3.36e-14 pd=7.6e-07 ps=7.6e-07 sa=1.4e-07 sb=1.4e-07 sca=35.0507 scb=0.0256051 scc=0.00441982 fw=2.4e-07 $X=61290 $Y=-13240 $dt=1
M119 116 43 VDD VDD g45p1svt w=2.4e-07 l=4.5e-08 ad=3.36e-14 as=3.36e-14 pd=7.6e-07 ps=7.6e-07 sa=1.4e-07 sb=1.4e-07 sca=35.0507 scb=0.0256051 scc=0.00441982 fw=2.4e-07 $X=61290 $Y=11090 $dt=1
M120 49 133 VDD VDD g45p1svt w=2.4e-07 l=4.5e-08 ad=3.36e-14 as=3.36e-14 pd=7.6e-07 ps=7.6e-07 sa=1.4e-07 sb=1.4e-07 sca=25.5159 scb=0.0267815 scc=0.00187996 fw=2.4e-07 $X=61760 $Y=-44700 $dt=1
M121 46 126 VDD VDD g45p1svt w=2.4e-07 l=4.5e-08 ad=3.36e-14 as=3.36e-14 pd=7.6e-07 ps=7.6e-07 sa=1.4e-07 sb=1.4e-07 sca=25.5159 scb=0.0267815 scc=0.00187996 fw=2.4e-07 $X=61760 $Y=-20730 $dt=1
M122 45 119 VDD VDD g45p1svt w=2.4e-07 l=4.5e-08 ad=3.36e-14 as=3.36e-14 pd=7.6e-07 ps=7.6e-07 sa=1.4e-07 sb=1.4e-07 sca=25.5159 scb=0.0267815 scc=0.00187996 fw=2.4e-07 $X=61760 $Y=3600 $dt=1
M123 P6 129 265 VDD g45p1svt w=4.8e-07 l=4.5e-08 ad=6.72e-14 as=6.72e-14 pd=1.24e-06 ps=1.24e-06 sa=1.4e-07 sb=1.4e-07 sca=12.8218 scb=0.0114511 scc=0.000406405 fw=4.8e-07 $X=61790 $Y=-39220 $dt=1
M124 38 122 261 VDD g45p1svt w=4.8e-07 l=4.5e-08 ad=6.72e-14 as=6.72e-14 pd=1.24e-06 ps=1.24e-06 sa=1.4e-07 sb=1.4e-07 sca=12.8218 scb=0.0114511 scc=0.000406405 fw=4.8e-07 $X=61790 $Y=-15250 $dt=1
M125 39 115 257 VDD g45p1svt w=4.8e-07 l=4.5e-08 ad=6.72e-14 as=6.72e-14 pd=1.24e-06 ps=1.24e-06 sa=1.4e-07 sb=1.4e-07 sca=12.8218 scb=0.0114511 scc=0.000406405 fw=4.8e-07 $X=61790 $Y=9080 $dt=1
.ends Multiplier

* +++++++++++++++++++++++++++++++++++++++++++++++++++++++++ *
* Sub cell: proc_el                                         *
* +++++++++++++++++++++++++++++++++++++++++++++++++++++++++ *
.subckt proc_el A0 A0P A1 A1P A2 A2P A3 A3P B0 B0P
+ B1 B1P B2 B2P B3 B3P GND PHI RST RSTP
+ S0 S1 S2 S3 S4 S5 S6 S7 VDD
** N=549 EP=29 FDC=1026
X195 VDD GND 10 PHI 36 B0P 63 484 485 291 FlipFlop $T=-62060 4010 0 0 $X=-65470 $Y=3610
X196 VDD GND 14 PHI 37 B1P 64 486 487 293 FlipFlop $T=-54100 4010 0 0 $X=-57510 $Y=3610
X197 VDD GND 15 PHI 38 B2P 65 488 489 295 FlipFlop $T=-46140 4010 0 0 $X=-49550 $Y=3610
X198 VDD GND 16 PHI 39 B3P 66 490 491 297 FlipFlop $T=-38180 4010 0 0 $X=-41590 $Y=3610
X199 VDD GND RST PHI 40 RSTP 67 492 493 299 FlipFlop $T=-30640 4010 0 0 $X=-34050 $Y=3610
X200 VDD GND 41 PHI 42 A0P 68 494 495 301 FlipFlop $T=-19180 99000 0 0 $X=-22590 $Y=98600
X201 VDD GND 43 PHI 44 A1P 69 496 497 303 FlipFlop $T=-7360 99000 0 0 $X=-10770 $Y=98600
X202 VDD GND 45 PHI 46 A2P 70 498 499 305 FlipFlop $T=4460 99000 0 0 $X=1050 $Y=98600
X203 VDD GND 47 PHI 48 A3P 71 500 501 307 FlipFlop $T=16280 99000 0 0 $X=12870 $Y=98600
X204 S7 20 49 GND VDD 19 RST PHI 83 73
+ 78 81 502 507 faabs $T=-11740 200 0 0 $X=-25550 $Y=-1240
X205 S6 51 20 GND VDD 29 RST PHI 95 85
+ 90 93 508 513 faabs $T=10190 200 0 0 $X=-3620 $Y=-1240
X206 S5 53 51 GND VDD 28 RST PHI 107 97
+ 102 105 514 519 faabs $T=10190 14290 0 0 $X=-3620 $Y=12850
X207 S4 55 53 GND VDD 27 RST PHI 119 109
+ 114 117 520 525 faabs $T=10190 28380 0 0 $X=-3620 $Y=26940
X208 S3 57 55 GND VDD 26 RST PHI 131 121
+ 126 129 526 531 faabs $T=10190 42460 0 0 $X=-3620 $Y=41020
X209 S2 59 57 GND VDD 23 RST PHI 143 133
+ 138 141 532 537 faabs $T=10190 56550 0 0 $X=-3620 $Y=55110
X210 S1 61 59 GND VDD 24 RST PHI 155 145
+ 150 153 538 543 faabs $T=10190 70640 0 0 $X=-3620 $Y=69200
X211 S0 GND 61 GND VDD 25 RST PHI 167 157
+ 162 165 544 549 faabs $T=10190 84730 0 0 $X=-3620 $Y=83290
X212 VDD GND B0 RST 10 168 AND $T=-62430 9930 0 0 $X=-65470 $Y=10080
X213 VDD GND B1 RST 14 169 AND $T=-54470 9930 0 0 $X=-57510 $Y=10080
X214 VDD GND B2 RST 15 170 AND $T=-46510 9930 0 0 $X=-49550 $Y=10080
X215 VDD GND B3 RST 16 171 AND $T=-38550 9920 0 0 $X=-41590 $Y=10070
X216 VDD GND A0 RST 41 172 AND $T=-23900 99020 0 0 $X=-26940 $Y=99170
X217 VDD GND A1 RST 43 173 AND $T=-11970 99020 0 0 $X=-15010 $Y=99170
X218 VDD GND A2 RST 45 174 AND $T=-150 99020 0 0 $X=-3190 $Y=99170
X219 VDD GND A3 RST 47 175 AND $T=11670 99020 0 0 $X=8630 $Y=99170
X220 A0 A1 A2 A3 B0 B1 B2 B3 25 GND
+ VDD 26 24 23 27 28 29 19 Multiplier $T=-72890 78510 0 0 $X=-65460 $Y=29370
M0 B0P PHI 291 GND g45n1svt w=2.4e-07 l=4.5e-08 ad=3.36e-14 as=3.36e-14 pd=7.6e-07 ps=7.6e-07 sa=1.4e-07 sb=1.4e-07 sca=3.52678 scb=0.000111658 scc=3.66286e-09 fw=2.4e-07 $X=-59740 $Y=4520 $dt=0
M1 B1P PHI 293 GND g45n1svt w=2.4e-07 l=4.5e-08 ad=3.36e-14 as=3.36e-14 pd=7.6e-07 ps=7.6e-07 sa=1.4e-07 sb=1.4e-07 sca=3.52678 scb=0.000111658 scc=3.66286e-09 fw=2.4e-07 $X=-51780 $Y=4520 $dt=0
M2 B2P PHI 295 GND g45n1svt w=2.4e-07 l=4.5e-08 ad=3.36e-14 as=3.36e-14 pd=7.6e-07 ps=7.6e-07 sa=1.4e-07 sb=1.4e-07 sca=3.52678 scb=0.000111658 scc=3.66286e-09 fw=2.4e-07 $X=-43820 $Y=4520 $dt=0
M3 B3P PHI 297 GND g45n1svt w=2.4e-07 l=4.5e-08 ad=3.36e-14 as=3.36e-14 pd=7.6e-07 ps=7.6e-07 sa=1.4e-07 sb=1.4e-07 sca=3.52678 scb=0.000111658 scc=3.66286e-09 fw=2.4e-07 $X=-35860 $Y=4520 $dt=0
M4 RSTP PHI 299 GND g45n1svt w=2.4e-07 l=4.5e-08 ad=3.36e-14 as=3.36e-14 pd=7.6e-07 ps=7.6e-07 sa=1.4e-07 sb=1.4e-07 sca=3.52678 scb=0.000111658 scc=3.66286e-09 fw=2.4e-07 $X=-28320 $Y=4520 $dt=0
M5 A0P PHI 301 GND g45n1svt w=2.4e-07 l=4.5e-08 ad=3.36e-14 as=3.36e-14 pd=7.6e-07 ps=7.6e-07 sa=1.4e-07 sb=1.4e-07 sca=3.52678 scb=0.000111658 scc=3.66286e-09 fw=2.4e-07 $X=-16860 $Y=99510 $dt=0
M6 A1P PHI 303 GND g45n1svt w=2.4e-07 l=4.5e-08 ad=3.36e-14 as=3.36e-14 pd=7.6e-07 ps=7.6e-07 sa=1.4e-07 sb=1.4e-07 sca=3.52678 scb=0.000111658 scc=3.66286e-09 fw=2.4e-07 $X=-5040 $Y=99510 $dt=0
M7 A2P PHI 305 GND g45n1svt w=2.4e-07 l=4.5e-08 ad=3.36e-14 as=3.36e-14 pd=7.6e-07 ps=7.6e-07 sa=1.4e-07 sb=1.4e-07 sca=3.52678 scb=0.000111658 scc=3.66286e-09 fw=2.4e-07 $X=6780 $Y=99510 $dt=0
M8 A3P PHI 307 GND g45n1svt w=2.4e-07 l=4.5e-08 ad=3.36e-14 as=3.36e-14 pd=7.6e-07 ps=7.6e-07 sa=1.4e-07 sb=1.4e-07 sca=3.96308 scb=0.000252284 scc=4.02703e-08 fw=2.4e-07 $X=18600 $Y=99510 $dt=0
M9 63 PHI VDD VDD g45p1svt w=2.4e-07 l=4.5e-08 ad=3.36e-14 as=3.36e-14 pd=7.6e-07 ps=7.6e-07 sa=1.4e-07 sb=1.4e-07 sca=15.0576 scb=0.0142053 scc=0.000386892 fw=2.4e-07 $X=-64560 $Y=7170 $dt=1
M10 168 RST VDD VDD g45p1svt w=2.4e-07 l=4.5e-08 ad=3.36e-14 as=3.36e-14 pd=7.6e-07 ps=7.6e-07 sa=1.4e-07 sb=1.4e-07 sca=16.0927 scb=0.0154531 scc=0.000419743 fw=2.4e-07 $X=-64540 $Y=12700 $dt=1
M11 484 10 VDD VDD g45p1svt w=4.8e-07 l=4.5e-08 ad=6.72e-14 as=6.72e-14 pd=1.24e-06 ps=1.24e-06 sa=1.4e-07 sb=1.4e-07 sca=16.1286 scb=0.0134283 scc=0.00129853 fw=4.8e-07 $X=-63320 $Y=6920 $dt=1
M12 36 PHI 484 VDD g45p1svt w=4.8e-07 l=4.5e-08 ad=6.72e-14 as=6.72e-14 pd=1.24e-06 ps=1.24e-06 sa=1.4e-07 sb=1.4e-07 sca=15.6391 scb=0.0131208 scc=0.00120734 fw=4.8e-07 $X=-62110 $Y=6930 $dt=1
M13 10 168 VDD VDD g45p1svt w=2.4e-07 l=4.5e-08 ad=3.36e-14 as=3.36e-14 pd=7.6e-07 ps=7.6e-07 sa=1.4e-07 sb=1.4e-07 sca=12.8329 scb=0.0117498 scc=0.000390557 fw=2.4e-07 $X=-62010 $Y=12700 $dt=1
M14 485 36 VDD VDD g45p1svt w=4.8e-07 l=4.5e-08 ad=6.72e-14 as=6.72e-14 pd=1.24e-06 ps=1.24e-06 sa=1.4e-07 sb=1.4e-07 sca=16.1286 scb=0.0134283 scc=0.00129853 fw=4.8e-07 $X=-60920 $Y=6920 $dt=1
M15 B0P 63 485 VDD g45p1svt w=4.8e-07 l=4.5e-08 ad=6.72e-14 as=6.72e-14 pd=1.24e-06 ps=1.24e-06 sa=1.4e-07 sb=1.4e-07 sca=15.6391 scb=0.0131208 scc=0.00120734 fw=4.8e-07 $X=-59740 $Y=6930 $dt=1
M16 64 PHI VDD VDD g45p1svt w=2.4e-07 l=4.5e-08 ad=3.36e-14 as=3.36e-14 pd=7.6e-07 ps=7.6e-07 sa=1.4e-07 sb=1.4e-07 sca=11.619 scb=0.0101937 scc=0.000351981 fw=2.4e-07 $X=-56600 $Y=7170 $dt=1
M17 169 RST VDD VDD g45p1svt w=2.4e-07 l=4.5e-08 ad=3.36e-14 as=3.36e-14 pd=7.6e-07 ps=7.6e-07 sa=1.4e-07 sb=1.4e-07 sca=12.8329 scb=0.0117498 scc=0.000390557 fw=2.4e-07 $X=-56580 $Y=12700 $dt=1
M18 486 14 VDD VDD g45p1svt w=4.8e-07 l=4.5e-08 ad=6.72e-14 as=6.72e-14 pd=1.24e-06 ps=1.24e-06 sa=1.4e-07 sb=1.4e-07 sca=16.1286 scb=0.0134283 scc=0.00129853 fw=4.8e-07 $X=-55360 $Y=6920 $dt=1
M19 37 PHI 486 VDD g45p1svt w=4.8e-07 l=4.5e-08 ad=6.72e-14 as=6.72e-14 pd=1.24e-06 ps=1.24e-06 sa=1.4e-07 sb=1.4e-07 sca=15.6391 scb=0.0131208 scc=0.00120734 fw=4.8e-07 $X=-54150 $Y=6930 $dt=1
M20 14 169 VDD VDD g45p1svt w=2.4e-07 l=4.5e-08 ad=3.36e-14 as=3.36e-14 pd=7.6e-07 ps=7.6e-07 sa=1.4e-07 sb=1.4e-07 sca=12.8329 scb=0.0117498 scc=0.000390557 fw=2.4e-07 $X=-54050 $Y=12700 $dt=1
M21 487 37 VDD VDD g45p1svt w=4.8e-07 l=4.5e-08 ad=6.72e-14 as=6.72e-14 pd=1.24e-06 ps=1.24e-06 sa=1.4e-07 sb=1.4e-07 sca=16.1286 scb=0.0134283 scc=0.00129853 fw=4.8e-07 $X=-52960 $Y=6920 $dt=1
M22 B1P 64 487 VDD g45p1svt w=4.8e-07 l=4.5e-08 ad=6.72e-14 as=6.72e-14 pd=1.24e-06 ps=1.24e-06 sa=1.4e-07 sb=1.4e-07 sca=15.6391 scb=0.0131208 scc=0.00120734 fw=4.8e-07 $X=-51780 $Y=6930 $dt=1
M23 65 PHI VDD VDD g45p1svt w=2.4e-07 l=4.5e-08 ad=3.36e-14 as=3.36e-14 pd=7.6e-07 ps=7.6e-07 sa=1.4e-07 sb=1.4e-07 sca=11.619 scb=0.0101937 scc=0.000351981 fw=2.4e-07 $X=-48640 $Y=7170 $dt=1
M24 170 RST VDD VDD g45p1svt w=2.4e-07 l=4.5e-08 ad=3.36e-14 as=3.36e-14 pd=7.6e-07 ps=7.6e-07 sa=1.4e-07 sb=1.4e-07 sca=12.8329 scb=0.0117498 scc=0.000390557 fw=2.4e-07 $X=-48620 $Y=12700 $dt=1
M25 488 15 VDD VDD g45p1svt w=4.8e-07 l=4.5e-08 ad=6.72e-14 as=6.72e-14 pd=1.24e-06 ps=1.24e-06 sa=1.4e-07 sb=1.4e-07 sca=16.1286 scb=0.0134283 scc=0.00129853 fw=4.8e-07 $X=-47400 $Y=6920 $dt=1
M26 38 PHI 488 VDD g45p1svt w=4.8e-07 l=4.5e-08 ad=6.72e-14 as=6.72e-14 pd=1.24e-06 ps=1.24e-06 sa=1.4e-07 sb=1.4e-07 sca=15.6391 scb=0.0131208 scc=0.00120734 fw=4.8e-07 $X=-46190 $Y=6930 $dt=1
M27 15 170 VDD VDD g45p1svt w=2.4e-07 l=4.5e-08 ad=3.36e-14 as=3.36e-14 pd=7.6e-07 ps=7.6e-07 sa=1.4e-07 sb=1.4e-07 sca=12.8329 scb=0.0117498 scc=0.000390557 fw=2.4e-07 $X=-46090 $Y=12700 $dt=1
M28 489 38 VDD VDD g45p1svt w=4.8e-07 l=4.5e-08 ad=6.72e-14 as=6.72e-14 pd=1.24e-06 ps=1.24e-06 sa=1.4e-07 sb=1.4e-07 sca=16.1286 scb=0.0134283 scc=0.00129853 fw=4.8e-07 $X=-45000 $Y=6920 $dt=1
M29 B2P 65 489 VDD g45p1svt w=4.8e-07 l=4.5e-08 ad=6.72e-14 as=6.72e-14 pd=1.24e-06 ps=1.24e-06 sa=1.4e-07 sb=1.4e-07 sca=15.6391 scb=0.0131208 scc=0.00120734 fw=4.8e-07 $X=-43820 $Y=6930 $dt=1
M30 66 PHI VDD VDD g45p1svt w=2.4e-07 l=4.5e-08 ad=3.36e-14 as=3.36e-14 pd=7.6e-07 ps=7.6e-07 sa=1.4e-07 sb=1.4e-07 sca=11.619 scb=0.0101937 scc=0.000351981 fw=2.4e-07 $X=-40680 $Y=7170 $dt=1
M31 171 RST VDD VDD g45p1svt w=2.4e-07 l=4.5e-08 ad=3.36e-14 as=3.36e-14 pd=7.6e-07 ps=7.6e-07 sa=1.4e-07 sb=1.4e-07 sca=12.8329 scb=0.0117498 scc=0.000390557 fw=2.4e-07 $X=-40660 $Y=12690 $dt=1
M32 490 16 VDD VDD g45p1svt w=4.8e-07 l=4.5e-08 ad=6.72e-14 as=6.72e-14 pd=1.24e-06 ps=1.24e-06 sa=1.4e-07 sb=1.4e-07 sca=16.1286 scb=0.0134283 scc=0.00129853 fw=4.8e-07 $X=-39440 $Y=6920 $dt=1
M33 39 PHI 490 VDD g45p1svt w=4.8e-07 l=4.5e-08 ad=6.72e-14 as=6.72e-14 pd=1.24e-06 ps=1.24e-06 sa=1.4e-07 sb=1.4e-07 sca=15.6391 scb=0.0131208 scc=0.00120734 fw=4.8e-07 $X=-38230 $Y=6930 $dt=1
M34 16 171 VDD VDD g45p1svt w=2.4e-07 l=4.5e-08 ad=3.36e-14 as=3.36e-14 pd=7.6e-07 ps=7.6e-07 sa=1.4e-07 sb=1.4e-07 sca=15.9246 scb=0.0151668 scc=0.000414946 fw=2.4e-07 $X=-38130 $Y=12690 $dt=1
M35 491 39 VDD VDD g45p1svt w=4.8e-07 l=4.5e-08 ad=6.72e-14 as=6.72e-14 pd=1.24e-06 ps=1.24e-06 sa=1.4e-07 sb=1.4e-07 sca=16.1286 scb=0.0134283 scc=0.00129853 fw=4.8e-07 $X=-37040 $Y=6920 $dt=1
M36 B3P 66 491 VDD g45p1svt w=4.8e-07 l=4.5e-08 ad=6.72e-14 as=6.72e-14 pd=1.24e-06 ps=1.24e-06 sa=1.4e-07 sb=1.4e-07 sca=15.6391 scb=0.0131208 scc=0.00120734 fw=4.8e-07 $X=-35860 $Y=6930 $dt=1
M37 67 PHI VDD VDD g45p1svt w=2.4e-07 l=4.5e-08 ad=3.36e-14 as=3.36e-14 pd=7.6e-07 ps=7.6e-07 sa=1.4e-07 sb=1.4e-07 sca=11.619 scb=0.0101937 scc=0.000351981 fw=2.4e-07 $X=-33140 $Y=7170 $dt=1
M38 492 RST VDD VDD g45p1svt w=4.8e-07 l=4.5e-08 ad=6.72e-14 as=6.72e-14 pd=1.24e-06 ps=1.24e-06 sa=1.4e-07 sb=1.4e-07 sca=16.1286 scb=0.0134283 scc=0.00129853 fw=4.8e-07 $X=-31900 $Y=6920 $dt=1
M39 40 PHI 492 VDD g45p1svt w=4.8e-07 l=4.5e-08 ad=6.72e-14 as=6.72e-14 pd=1.24e-06 ps=1.24e-06 sa=1.4e-07 sb=1.4e-07 sca=15.6391 scb=0.0131208 scc=0.00120734 fw=4.8e-07 $X=-30690 $Y=6930 $dt=1
M40 493 40 VDD VDD g45p1svt w=4.8e-07 l=4.5e-08 ad=6.72e-14 as=6.72e-14 pd=1.24e-06 ps=1.24e-06 sa=1.4e-07 sb=1.4e-07 sca=16.1286 scb=0.0134283 scc=0.00129853 fw=4.8e-07 $X=-29500 $Y=6920 $dt=1
M41 RSTP 67 493 VDD g45p1svt w=4.8e-07 l=4.5e-08 ad=6.72e-14 as=6.72e-14 pd=1.24e-06 ps=1.24e-06 sa=1.4e-07 sb=1.4e-07 sca=18.4233 scb=0.0160258 scc=0.00122435 fw=4.8e-07 $X=-28320 $Y=6930 $dt=1
M42 172 RST VDD VDD g45p1svt w=2.4e-07 l=4.5e-08 ad=3.36e-14 as=3.36e-14 pd=7.6e-07 ps=7.6e-07 sa=1.4e-07 sb=1.4e-07 sca=14.8024 scb=0.0139872 scc=0.00040819 fw=2.4e-07 $X=-26010 $Y=101790 $dt=1
M43 78 S7 VDD VDD g45p1svt w=2.4e-07 l=4.5e-08 ad=3.36e-14 as=3.36e-14 pd=7.6e-07 ps=7.6e-07 sa=1.4e-07 sb=1.4e-07 sca=15.0046 scb=0.0138563 scc=0.000630427 fw=2.4e-07 $X=-23870 $Y=2600 $dt=1
M44 502 S7 VDD VDD g45p1svt w=4.8e-07 l=4.5e-08 ad=6.72e-14 as=6.72e-14 pd=1.24e-06 ps=1.24e-06 sa=1.4e-07 sb=1.4e-07 sca=9.68014 scb=0.0076467 scc=0.00037449 fw=4.8e-07 $X=-23740 $Y=8080 $dt=1
M45 73 19 VDD VDD g45p1svt w=2.4e-07 l=4.5e-08 ad=3.36e-14 as=3.36e-14 pd=7.6e-07 ps=7.6e-07 sa=1.4e-07 sb=1.4e-07 sca=34.3359 scb=0.0252032 scc=0.0044195 fw=2.4e-07 $X=-23730 $Y=10090 $dt=1
M46 41 172 VDD VDD g45p1svt w=2.4e-07 l=4.5e-08 ad=3.36e-14 as=3.36e-14 pd=7.6e-07 ps=7.6e-07 sa=1.4e-07 sb=1.4e-07 sca=12.8329 scb=0.0117498 scc=0.000390557 fw=2.4e-07 $X=-23480 $Y=101790 $dt=1
M47 68 PHI VDD VDD g45p1svt w=2.4e-07 l=4.5e-08 ad=3.36e-14 as=3.36e-14 pd=7.6e-07 ps=7.6e-07 sa=1.4e-07 sb=1.4e-07 sca=11.619 scb=0.0101937 scc=0.000351981 fw=2.4e-07 $X=-21680 $Y=102160 $dt=1
M48 494 41 VDD VDD g45p1svt w=4.8e-07 l=4.5e-08 ad=6.72e-14 as=6.72e-14 pd=1.24e-06 ps=1.24e-06 sa=1.4e-07 sb=1.4e-07 sca=16.1286 scb=0.0134283 scc=0.00129853 fw=4.8e-07 $X=-20440 $Y=101910 $dt=1
M49 42 PHI 494 VDD g45p1svt w=4.8e-07 l=4.5e-08 ad=6.72e-14 as=6.72e-14 pd=1.24e-06 ps=1.24e-06 sa=1.4e-07 sb=1.4e-07 sca=15.6391 scb=0.0131208 scc=0.00120734 fw=4.8e-07 $X=-19230 $Y=101920 $dt=1
M50 495 42 VDD VDD g45p1svt w=4.8e-07 l=4.5e-08 ad=6.72e-14 as=6.72e-14 pd=1.24e-06 ps=1.24e-06 sa=1.4e-07 sb=1.4e-07 sca=16.1286 scb=0.0134283 scc=0.00129853 fw=4.8e-07 $X=-18040 $Y=101910 $dt=1
M51 A0P 68 495 VDD g45p1svt w=4.8e-07 l=4.5e-08 ad=6.72e-14 as=6.72e-14 pd=1.24e-06 ps=1.24e-06 sa=1.4e-07 sb=1.4e-07 sca=15.6391 scb=0.0131208 scc=0.00120734 fw=4.8e-07 $X=-16860 $Y=101920 $dt=1
M52 173 RST VDD VDD g45p1svt w=2.4e-07 l=4.5e-08 ad=3.36e-14 as=3.36e-14 pd=7.6e-07 ps=7.6e-07 sa=1.4e-07 sb=1.4e-07 sca=12.8329 scb=0.0117498 scc=0.000390557 fw=2.4e-07 $X=-14080 $Y=101790 $dt=1
M53 43 173 VDD VDD g45p1svt w=2.4e-07 l=4.5e-08 ad=3.36e-14 as=3.36e-14 pd=7.6e-07 ps=7.6e-07 sa=1.4e-07 sb=1.4e-07 sca=12.8329 scb=0.0117498 scc=0.000390557 fw=2.4e-07 $X=-11550 $Y=101790 $dt=1
M54 69 PHI VDD VDD g45p1svt w=2.4e-07 l=4.5e-08 ad=3.36e-14 as=3.36e-14 pd=7.6e-07 ps=7.6e-07 sa=1.4e-07 sb=1.4e-07 sca=11.619 scb=0.0101937 scc=0.000351981 fw=2.4e-07 $X=-9860 $Y=102160 $dt=1
M55 496 43 VDD VDD g45p1svt w=4.8e-07 l=4.5e-08 ad=6.72e-14 as=6.72e-14 pd=1.24e-06 ps=1.24e-06 sa=1.4e-07 sb=1.4e-07 sca=16.1286 scb=0.0134283 scc=0.00129853 fw=4.8e-07 $X=-8620 $Y=101910 $dt=1
M56 44 PHI 496 VDD g45p1svt w=4.8e-07 l=4.5e-08 ad=6.72e-14 as=6.72e-14 pd=1.24e-06 ps=1.24e-06 sa=1.4e-07 sb=1.4e-07 sca=15.6391 scb=0.0131208 scc=0.00120734 fw=4.8e-07 $X=-7410 $Y=101920 $dt=1
M57 497 44 VDD VDD g45p1svt w=4.8e-07 l=4.5e-08 ad=6.72e-14 as=6.72e-14 pd=1.24e-06 ps=1.24e-06 sa=1.4e-07 sb=1.4e-07 sca=16.1286 scb=0.0134283 scc=0.00129853 fw=4.8e-07 $X=-6220 $Y=101910 $dt=1
M58 83 81 507 VDD g45p1svt w=4.8e-07 l=4.5e-08 ad=6.72e-14 as=6.72e-14 pd=1.24e-06 ps=1.24e-06 sa=1.4e-07 sb=1.4e-07 sca=13.3978 scb=0.0114602 scc=0.001037 fw=4.8e-07 $X=-5120 $Y=8100 $dt=1
M59 A1P 69 497 VDD g45p1svt w=4.8e-07 l=4.5e-08 ad=6.72e-14 as=6.72e-14 pd=1.24e-06 ps=1.24e-06 sa=1.4e-07 sb=1.4e-07 sca=15.6391 scb=0.0131208 scc=0.00120734 fw=4.8e-07 $X=-5040 $Y=101920 $dt=1
M60 174 RST VDD VDD g45p1svt w=2.4e-07 l=4.5e-08 ad=3.36e-14 as=3.36e-14 pd=7.6e-07 ps=7.6e-07 sa=1.4e-07 sb=1.4e-07 sca=12.8329 scb=0.0117498 scc=0.000390557 fw=2.4e-07 $X=-2260 $Y=101790 $dt=1
M61 90 S6 VDD VDD g45p1svt w=2.4e-07 l=4.5e-08 ad=3.36e-14 as=3.36e-14 pd=7.6e-07 ps=7.6e-07 sa=1.4e-07 sb=1.4e-07 sca=13.9617 scb=0.0132915 scc=0.000629907 fw=2.4e-07 $X=-1940 $Y=2600 $dt=1
M62 102 S5 VDD VDD g45p1svt w=2.4e-07 l=4.5e-08 ad=3.36e-14 as=3.36e-14 pd=7.6e-07 ps=7.6e-07 sa=1.4e-07 sb=1.4e-07 sca=15.0046 scb=0.0138563 scc=0.000630427 fw=2.4e-07 $X=-1940 $Y=16690 $dt=1
M63 114 S4 VDD VDD g45p1svt w=2.4e-07 l=4.5e-08 ad=3.36e-14 as=3.36e-14 pd=7.6e-07 ps=7.6e-07 sa=1.4e-07 sb=1.4e-07 sca=15.0046 scb=0.0138563 scc=0.000630427 fw=2.4e-07 $X=-1940 $Y=30780 $dt=1
M64 126 S3 VDD VDD g45p1svt w=2.4e-07 l=4.5e-08 ad=3.36e-14 as=3.36e-14 pd=7.6e-07 ps=7.6e-07 sa=1.4e-07 sb=1.4e-07 sca=15.0046 scb=0.0138563 scc=0.000630427 fw=2.4e-07 $X=-1940 $Y=44860 $dt=1
M65 138 S2 VDD VDD g45p1svt w=2.4e-07 l=4.5e-08 ad=3.36e-14 as=3.36e-14 pd=7.6e-07 ps=7.6e-07 sa=1.4e-07 sb=1.4e-07 sca=15.0046 scb=0.0138563 scc=0.000630427 fw=2.4e-07 $X=-1940 $Y=58950 $dt=1
M66 150 S1 VDD VDD g45p1svt w=2.4e-07 l=4.5e-08 ad=3.36e-14 as=3.36e-14 pd=7.6e-07 ps=7.6e-07 sa=1.4e-07 sb=1.4e-07 sca=15.0046 scb=0.0138563 scc=0.000630427 fw=2.4e-07 $X=-1940 $Y=73040 $dt=1
M67 162 S0 VDD VDD g45p1svt w=2.4e-07 l=4.5e-08 ad=3.36e-14 as=3.36e-14 pd=7.6e-07 ps=7.6e-07 sa=1.4e-07 sb=1.4e-07 sca=15.0046 scb=0.0138563 scc=0.000630427 fw=2.4e-07 $X=-1940 $Y=87130 $dt=1
M68 508 S6 VDD VDD g45p1svt w=4.8e-07 l=4.5e-08 ad=6.72e-14 as=6.72e-14 pd=1.24e-06 ps=1.24e-06 sa=1.4e-07 sb=1.4e-07 sca=9.47395 scb=0.00759651 scc=0.000374483 fw=4.8e-07 $X=-1810 $Y=8080 $dt=1
M69 514 S5 VDD VDD g45p1svt w=4.8e-07 l=4.5e-08 ad=6.72e-14 as=6.72e-14 pd=1.24e-06 ps=1.24e-06 sa=1.4e-07 sb=1.4e-07 sca=9.68014 scb=0.0076467 scc=0.00037449 fw=4.8e-07 $X=-1810 $Y=22170 $dt=1
M70 520 S4 VDD VDD g45p1svt w=4.8e-07 l=4.5e-08 ad=6.72e-14 as=6.72e-14 pd=1.24e-06 ps=1.24e-06 sa=1.4e-07 sb=1.4e-07 sca=9.68014 scb=0.0076467 scc=0.00037449 fw=4.8e-07 $X=-1810 $Y=36260 $dt=1
M71 526 S3 VDD VDD g45p1svt w=4.8e-07 l=4.5e-08 ad=6.72e-14 as=6.72e-14 pd=1.24e-06 ps=1.24e-06 sa=1.4e-07 sb=1.4e-07 sca=9.68014 scb=0.0076467 scc=0.00037449 fw=4.8e-07 $X=-1810 $Y=50340 $dt=1
M72 532 S2 VDD VDD g45p1svt w=4.8e-07 l=4.5e-08 ad=6.72e-14 as=6.72e-14 pd=1.24e-06 ps=1.24e-06 sa=1.4e-07 sb=1.4e-07 sca=9.68014 scb=0.0076467 scc=0.00037449 fw=4.8e-07 $X=-1810 $Y=64430 $dt=1
M73 538 S1 VDD VDD g45p1svt w=4.8e-07 l=4.5e-08 ad=6.72e-14 as=6.72e-14 pd=1.24e-06 ps=1.24e-06 sa=1.4e-07 sb=1.4e-07 sca=9.68014 scb=0.0076467 scc=0.00037449 fw=4.8e-07 $X=-1810 $Y=78520 $dt=1
M74 544 S0 VDD VDD g45p1svt w=4.8e-07 l=4.5e-08 ad=6.72e-14 as=6.72e-14 pd=1.24e-06 ps=1.24e-06 sa=1.4e-07 sb=1.4e-07 sca=9.68014 scb=0.0076467 scc=0.00037449 fw=4.8e-07 $X=-1810 $Y=92610 $dt=1
M75 85 29 VDD VDD g45p1svt w=2.4e-07 l=4.5e-08 ad=3.36e-14 as=3.36e-14 pd=7.6e-07 ps=7.6e-07 sa=1.4e-07 sb=1.4e-07 sca=34.1422 scb=0.0251568 scc=0.00441949 fw=2.4e-07 $X=-1800 $Y=10090 $dt=1
M76 97 28 VDD VDD g45p1svt w=2.4e-07 l=4.5e-08 ad=3.36e-14 as=3.36e-14 pd=7.6e-07 ps=7.6e-07 sa=1.4e-07 sb=1.4e-07 sca=34.3359 scb=0.0252032 scc=0.0044195 fw=2.4e-07 $X=-1800 $Y=24180 $dt=1
M77 109 27 VDD VDD g45p1svt w=2.4e-07 l=4.5e-08 ad=3.36e-14 as=3.36e-14 pd=7.6e-07 ps=7.6e-07 sa=1.4e-07 sb=1.4e-07 sca=34.3359 scb=0.0252032 scc=0.0044195 fw=2.4e-07 $X=-1800 $Y=38270 $dt=1
M78 121 26 VDD VDD g45p1svt w=2.4e-07 l=4.5e-08 ad=3.36e-14 as=3.36e-14 pd=7.6e-07 ps=7.6e-07 sa=1.4e-07 sb=1.4e-07 sca=34.3359 scb=0.0252032 scc=0.0044195 fw=2.4e-07 $X=-1800 $Y=52350 $dt=1
M79 133 23 VDD VDD g45p1svt w=2.4e-07 l=4.5e-08 ad=3.36e-14 as=3.36e-14 pd=7.6e-07 ps=7.6e-07 sa=1.4e-07 sb=1.4e-07 sca=34.3359 scb=0.0252032 scc=0.0044195 fw=2.4e-07 $X=-1800 $Y=66440 $dt=1
M80 145 24 VDD VDD g45p1svt w=2.4e-07 l=4.5e-08 ad=3.36e-14 as=3.36e-14 pd=7.6e-07 ps=7.6e-07 sa=1.4e-07 sb=1.4e-07 sca=34.3359 scb=0.0252032 scc=0.0044195 fw=2.4e-07 $X=-1800 $Y=80530 $dt=1
M81 157 25 VDD VDD g45p1svt w=2.4e-07 l=4.5e-08 ad=3.36e-14 as=3.36e-14 pd=7.6e-07 ps=7.6e-07 sa=1.4e-07 sb=1.4e-07 sca=34.3359 scb=0.0252032 scc=0.0044195 fw=2.4e-07 $X=-1800 $Y=94620 $dt=1
M82 45 174 VDD VDD g45p1svt w=2.4e-07 l=4.5e-08 ad=3.36e-14 as=3.36e-14 pd=7.6e-07 ps=7.6e-07 sa=1.4e-07 sb=1.4e-07 sca=12.8329 scb=0.0117498 scc=0.000390557 fw=2.4e-07 $X=270 $Y=101790 $dt=1
M83 70 PHI VDD VDD g45p1svt w=2.4e-07 l=4.5e-08 ad=3.36e-14 as=3.36e-14 pd=7.6e-07 ps=7.6e-07 sa=1.4e-07 sb=1.4e-07 sca=11.619 scb=0.0101937 scc=0.000351981 fw=2.4e-07 $X=1960 $Y=102160 $dt=1
M84 498 45 VDD VDD g45p1svt w=4.8e-07 l=4.5e-08 ad=6.72e-14 as=6.72e-14 pd=1.24e-06 ps=1.24e-06 sa=1.4e-07 sb=1.4e-07 sca=16.1286 scb=0.0134283 scc=0.00129853 fw=4.8e-07 $X=3200 $Y=101910 $dt=1
M85 46 PHI 498 VDD g45p1svt w=4.8e-07 l=4.5e-08 ad=6.72e-14 as=6.72e-14 pd=1.24e-06 ps=1.24e-06 sa=1.4e-07 sb=1.4e-07 sca=15.6391 scb=0.0131208 scc=0.00120734 fw=4.8e-07 $X=4410 $Y=101920 $dt=1
M86 499 46 VDD VDD g45p1svt w=4.8e-07 l=4.5e-08 ad=6.72e-14 as=6.72e-14 pd=1.24e-06 ps=1.24e-06 sa=1.4e-07 sb=1.4e-07 sca=16.1286 scb=0.0134283 scc=0.00129853 fw=4.8e-07 $X=5600 $Y=101910 $dt=1
M87 A2P 70 499 VDD g45p1svt w=4.8e-07 l=4.5e-08 ad=6.72e-14 as=6.72e-14 pd=1.24e-06 ps=1.24e-06 sa=1.4e-07 sb=1.4e-07 sca=15.6391 scb=0.0131208 scc=0.00120734 fw=4.8e-07 $X=6780 $Y=101920 $dt=1
M88 175 RST VDD VDD g45p1svt w=2.4e-07 l=4.5e-08 ad=3.36e-14 as=3.36e-14 pd=7.6e-07 ps=7.6e-07 sa=1.4e-07 sb=1.4e-07 sca=12.8329 scb=0.0117498 scc=0.000390557 fw=2.4e-07 $X=9560 $Y=101790 $dt=1
M89 47 175 VDD VDD g45p1svt w=2.4e-07 l=4.5e-08 ad=3.36e-14 as=3.36e-14 pd=7.6e-07 ps=7.6e-07 sa=1.4e-07 sb=1.4e-07 sca=12.8329 scb=0.0117498 scc=0.000390557 fw=2.4e-07 $X=12090 $Y=101790 $dt=1
M90 71 PHI VDD VDD g45p1svt w=2.4e-07 l=4.5e-08 ad=3.36e-14 as=3.36e-14 pd=7.6e-07 ps=7.6e-07 sa=1.4e-07 sb=1.4e-07 sca=11.619 scb=0.0101937 scc=0.000351981 fw=2.4e-07 $X=13780 $Y=102160 $dt=1
M91 500 47 VDD VDD g45p1svt w=4.8e-07 l=4.5e-08 ad=6.72e-14 as=6.72e-14 pd=1.24e-06 ps=1.24e-06 sa=1.4e-07 sb=1.4e-07 sca=16.1286 scb=0.0134283 scc=0.00129853 fw=4.8e-07 $X=15020 $Y=101910 $dt=1
M92 48 PHI 500 VDD g45p1svt w=4.8e-07 l=4.5e-08 ad=6.72e-14 as=6.72e-14 pd=1.24e-06 ps=1.24e-06 sa=1.4e-07 sb=1.4e-07 sca=15.6391 scb=0.0131208 scc=0.00120734 fw=4.8e-07 $X=16230 $Y=101920 $dt=1
M93 95 93 513 VDD g45p1svt w=4.8e-07 l=4.5e-08 ad=6.72e-14 as=6.72e-14 pd=1.24e-06 ps=1.24e-06 sa=1.4e-07 sb=1.4e-07 sca=13.9023 scb=0.0116351 scc=0.00103705 fw=4.8e-07 $X=16810 $Y=8100 $dt=1
M94 107 105 519 VDD g45p1svt w=4.8e-07 l=4.5e-08 ad=6.72e-14 as=6.72e-14 pd=1.24e-06 ps=1.24e-06 sa=1.4e-07 sb=1.4e-07 sca=13.9023 scb=0.0116351 scc=0.00103705 fw=4.8e-07 $X=16810 $Y=22190 $dt=1
M95 119 117 525 VDD g45p1svt w=4.8e-07 l=4.5e-08 ad=6.72e-14 as=6.72e-14 pd=1.24e-06 ps=1.24e-06 sa=1.4e-07 sb=1.4e-07 sca=13.9023 scb=0.0116351 scc=0.00103705 fw=4.8e-07 $X=16810 $Y=36280 $dt=1
M96 131 129 531 VDD g45p1svt w=4.8e-07 l=4.5e-08 ad=6.72e-14 as=6.72e-14 pd=1.24e-06 ps=1.24e-06 sa=1.4e-07 sb=1.4e-07 sca=13.9023 scb=0.0116351 scc=0.00103705 fw=4.8e-07 $X=16810 $Y=50360 $dt=1
M97 143 141 537 VDD g45p1svt w=4.8e-07 l=4.5e-08 ad=6.72e-14 as=6.72e-14 pd=1.24e-06 ps=1.24e-06 sa=1.4e-07 sb=1.4e-07 sca=13.9023 scb=0.0116351 scc=0.00103705 fw=4.8e-07 $X=16810 $Y=64450 $dt=1
M98 155 153 543 VDD g45p1svt w=4.8e-07 l=4.5e-08 ad=6.72e-14 as=6.72e-14 pd=1.24e-06 ps=1.24e-06 sa=1.4e-07 sb=1.4e-07 sca=13.9023 scb=0.0116351 scc=0.00103705 fw=4.8e-07 $X=16810 $Y=78540 $dt=1
M99 167 165 549 VDD g45p1svt w=4.8e-07 l=4.5e-08 ad=6.72e-14 as=6.72e-14 pd=1.24e-06 ps=1.24e-06 sa=1.4e-07 sb=1.4e-07 sca=13.9023 scb=0.0116351 scc=0.00103705 fw=4.8e-07 $X=16810 $Y=92630 $dt=1
M100 501 48 VDD VDD g45p1svt w=4.8e-07 l=4.5e-08 ad=6.72e-14 as=6.72e-14 pd=1.24e-06 ps=1.24e-06 sa=1.4e-07 sb=1.4e-07 sca=16.1286 scb=0.0134283 scc=0.00129853 fw=4.8e-07 $X=17420 $Y=101910 $dt=1
M101 A3P 71 501 VDD g45p1svt w=4.8e-07 l=4.5e-08 ad=6.72e-14 as=6.72e-14 pd=1.24e-06 ps=1.24e-06 sa=1.4e-07 sb=1.4e-07 sca=18.4233 scb=0.0160258 scc=0.00122435 fw=4.8e-07 $X=18600 $Y=101920 $dt=1
.ends proc_el
