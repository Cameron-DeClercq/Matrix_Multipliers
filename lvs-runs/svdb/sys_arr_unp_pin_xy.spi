* +++++++++++++++++++++++++++++++++++++++++++++++++++++++++ *
* CDL Netlist:                                              *
*                                                           *
* Cell Name  : sys_arr_unp                                  *
* Netlisted  : Thu May  8 15:24:11 2025                     *
* Pegasus Version: 22.20-p009 Wed Jan 18 17:06:09 PST 2023  *
* +++++++++++++++++++++++++++++++++++++++++++++++++++++++++ *
*.LDD
*.DEVTMPLT 0 M(g45n1svt) _nmos1v ndiff_conn(D) poly_conn(G) ndiff_conn(S) psubstrate(B)
*.DEVTMPLT 1 M(g45p1svt) _pmos1v pdiff_conn(D) poly_conn(G) pdiff_conn(S) nwell_conn(B)

* +++++++++++++++++++++++++++++++++++++++++++++++++++++++++ *
* Sub cell: M2_M1_CDNS_1                                    *
* +++++++++++++++++++++++++++++++++++++++++++++++++++++++++ *
.subckt M2_M1_CDNS_1 1
** N=1 EP=1 FDC=0
.ends M2_M1_CDNS_1

* +++++++++++++++++++++++++++++++++++++++++++++++++++++++++ *
* Sub cell: M2_M1_CDNS_2                                    *
* +++++++++++++++++++++++++++++++++++++++++++++++++++++++++ *
.subckt M2_M1_CDNS_2 1
** N=1 EP=1 FDC=0
.ends M2_M1_CDNS_2

* +++++++++++++++++++++++++++++++++++++++++++++++++++++++++ *
* Sub cell: M2_M1_CDNS_3                                    *
* +++++++++++++++++++++++++++++++++++++++++++++++++++++++++ *
.subckt M2_M1_CDNS_3 1
** N=1 EP=1 FDC=0
.ends M2_M1_CDNS_3

* +++++++++++++++++++++++++++++++++++++++++++++++++++++++++ *
* Sub cell: M1_PO_CDNS_4                                    *
* +++++++++++++++++++++++++++++++++++++++++++++++++++++++++ *
.subckt M1_PO_CDNS_4 1
** N=1 EP=1 FDC=0
.ends M1_PO_CDNS_4

* +++++++++++++++++++++++++++++++++++++++++++++++++++++++++ *
* Sub cell: M1_NWELL_CDNS_5                                 *
* +++++++++++++++++++++++++++++++++++++++++++++++++++++++++ *
.subckt M1_NWELL_CDNS_5 1
** N=1 EP=1 FDC=0
.ends M1_NWELL_CDNS_5

* +++++++++++++++++++++++++++++++++++++++++++++++++++++++++ *
* Sub cell: M1_PSUB_CDNS_6                                  *
* +++++++++++++++++++++++++++++++++++++++++++++++++++++++++ *
.subckt M1_PSUB_CDNS_6 1
** N=1 EP=1 FDC=0
.ends M1_PSUB_CDNS_6

* +++++++++++++++++++++++++++++++++++++++++++++++++++++++++ *
* Sub cell: pmos1v_CDNS_7                                   *
* +++++++++++++++++++++++++++++++++++++++++++++++++++++++++ *
.subckt pmos1v_CDNS_7 1 2 3 4 5
*.DEVICECLIMB
** N=5 EP=5 FDC=0
.ends pmos1v_CDNS_7

* +++++++++++++++++++++++++++++++++++++++++++++++++++++++++ *
* Sub cell: nmos1v_CDNS_8                                   *
* +++++++++++++++++++++++++++++++++++++++++++++++++++++++++ *
.subckt nmos1v_CDNS_8 1 2 3 4
*.DEVICECLIMB
** N=4 EP=4 FDC=0
.ends nmos1v_CDNS_8

* +++++++++++++++++++++++++++++++++++++++++++++++++++++++++ *
* Sub cell: nmos1v_CDNS_9                                   *
* +++++++++++++++++++++++++++++++++++++++++++++++++++++++++ *
.subckt nmos1v_CDNS_9 1 2 3
** N=3 EP=3 FDC=1
M0 2 3 1 1 g45n1svt w=1.2e-07 l=4.5e-08 ad=1.68e-14 as=1.68e-14 pd=5.2e-07 ps=5.2e-07 sa=1.4e-07 sb=1.4e-07 sca=3.69959 scb=0.00013007 scc=4.39142e-09 fw=1.2e-07 $X=0 $Y=0 $dt=0
.ends nmos1v_CDNS_9

* +++++++++++++++++++++++++++++++++++++++++++++++++++++++++ *
* Sub cell: pmos1v_CDNS_10                                  *
* +++++++++++++++++++++++++++++++++++++++++++++++++++++++++ *
.subckt pmos1v_CDNS_10 1 2 3 4
*.DEVICECLIMB
** N=4 EP=4 FDC=0
.ends pmos1v_CDNS_10

* +++++++++++++++++++++++++++++++++++++++++++++++++++++++++ *
* Sub cell: FlipFlop                                        *
* +++++++++++++++++++++++++++++++++++++++++++++++++++++++++ *
.subckt FlipFlop 1 2 3 4 5 6 7 8 9 10
+ 11
*.DEVICECLIMB
** N=11 EP=11 FDC=4
X0 2 M2_M1_CDNS_1 $T=-2660 -120 0 0 $X=-2740 $Y=-250
X1 1 M2_M1_CDNS_1 $T=-2660 4390 0 0 $X=-2740 $Y=4260
X2 7 M2_M1_CDNS_1 $T=-2250 1340 0 0 $X=-2330 $Y=1210
X3 1 M2_M1_CDNS_1 $T=-1420 4420 0 0 $X=-1500 $Y=4290
X4 2 M2_M1_CDNS_1 $T=-1410 -110 0 0 $X=-1490 $Y=-240
X5 4 M2_M1_CDNS_1 $T=-450 2130 0 0 $X=-530 $Y=2000
X6 4 M2_M1_CDNS_1 $T=-450 2560 0 0 $X=-530 $Y=2430
X7 5 M2_M1_CDNS_1 $T=200 1720 0 0 $X=120 $Y=1590
X8 7 M2_M1_CDNS_1 $T=530 1330 0 0 $X=450 $Y=1200
X9 7 M2_M1_CDNS_1 $T=530 2570 0 0 $X=450 $Y=2440
X10 1 M2_M1_CDNS_1 $T=980 4420 0 0 $X=900 $Y=4290
X11 2 M2_M1_CDNS_1 $T=990 -110 0 0 $X=910 $Y=-240
X12 4 M2_M1_CDNS_1 $T=1770 1330 0 0 $X=1690 $Y=1200
X13 4 M2_M1_CDNS_1 $T=1770 2130 0 0 $X=1690 $Y=2000
X14 6 M2_M1_CDNS_1 $T=2570 2090 0 0 $X=2490 $Y=1960
X15 2 M2_M1_CDNS_2 $T=-2660 760 0 0 $X=-2740 $Y=490
X16 1 M2_M1_CDNS_2 $T=-2660 3400 0 0 $X=-2740 $Y=3130
X17 7 M2_M1_CDNS_2 $T=-2250 760 0 0 $X=-2330 $Y=490
X18 7 M2_M1_CDNS_2 $T=-2250 3400 0 0 $X=-2330 $Y=3130
X19 2 M2_M1_CDNS_2 $T=-1410 760 0 0 $X=-1490 $Y=490
X20 5 M2_M1_CDNS_2 $T=200 750 0 0 $X=120 $Y=480
X21 2 M2_M1_CDNS_2 $T=990 760 0 0 $X=910 $Y=490
X22 6 M2_M1_CDNS_2 $T=2570 750 0 0 $X=2490 $Y=480
X23 1 M2_M1_CDNS_3 $T=-1420 3380 0 0 $X=-1500 $Y=2830
X24 5 M2_M1_CDNS_3 $T=200 3400 0 0 $X=120 $Y=2850
X25 1 M2_M1_CDNS_3 $T=980 3380 0 0 $X=900 $Y=2830
X26 6 M2_M1_CDNS_3 $T=2570 3400 0 0 $X=2490 $Y=2850
X27 4 M1_PO_CDNS_4 $T=-2450 2560 0 0 $X=-2550 $Y=2440
X28 3 M1_PO_CDNS_4 $T=-1210 1715 0 0 $X=-1310 $Y=1595
X29 7 M1_PO_CDNS_4 $T=-5 1330 0 0 $X=-105 $Y=1210
X30 4 M1_PO_CDNS_4 $T=-5 2570 0 0 $X=-105 $Y=2450
X31 5 M1_PO_CDNS_4 $T=1180 1715 0 0 $X=1080 $Y=1595
X32 4 M1_PO_CDNS_4 $T=2365 1330 0 0 $X=2265 $Y=1210
X33 7 M1_PO_CDNS_4 $T=2365 2570 0 0 $X=2265 $Y=2450
X34 1 M1_NWELL_CDNS_5 $T=-620 4440 0 0 $X=-920 $Y=4060
X35 2 M1_PSUB_CDNS_6 $T=-560 -120 0 0 $X=-820 $Y=-400
X36 1 8 3 2 1 pmos1v_CDNS_7 $T=-1260 2910 0 0 $X=-1680 $Y=2710
X37 8 5 4 2 1 pmos1v_CDNS_7 $T=-50 2920 0 0 $X=-470 $Y=2720
X38 1 9 5 2 1 pmos1v_CDNS_7 $T=1140 2910 0 0 $X=720 $Y=2710
X39 9 6 7 2 1 pmos1v_CDNS_7 $T=2320 2920 0 0 $X=1900 $Y=2720
X40 2 3 10 2 nmos1v_CDNS_8 $T=-1260 510 0 0 $X=-1680 $Y=310
X41 10 7 5 2 nmos1v_CDNS_8 $T=-50 510 0 0 $X=-470 $Y=310
X42 2 5 11 2 nmos1v_CDNS_8 $T=1140 510 0 0 $X=720 $Y=310
X43 11 4 6 2 nmos1v_CDNS_8 $T=2320 510 0 0 $X=1900 $Y=310
X44 2 7 4 nmos1v_CDNS_9 $T=-2500 640 0 0 $X=-2920 $Y=440
X45 1 4 7 2 pmos1v_CDNS_10 $T=-2500 3160 0 0 $X=-2920 $Y=2960
M0 10 3 2 2 g45n1svt w=2.4e-07 l=4.5e-08 ad=3.36e-14 as=3.36e-14 pd=7.6e-07 ps=7.6e-07 sa=1.4e-07 sb=1.4e-07 sca=3.52678 scb=0.000111658 scc=3.66286e-09 fw=2.4e-07 $X=-1260 $Y=510 $dt=0
M1 5 7 10 2 g45n1svt w=2.4e-07 l=4.5e-08 ad=3.36e-14 as=3.36e-14 pd=7.6e-07 ps=7.6e-07 sa=1.4e-07 sb=1.4e-07 sca=3.52678 scb=0.000111658 scc=3.66286e-09 fw=2.4e-07 $X=-50 $Y=510 $dt=0
M2 11 5 2 2 g45n1svt w=2.4e-07 l=4.5e-08 ad=3.36e-14 as=3.36e-14 pd=7.6e-07 ps=7.6e-07 sa=1.4e-07 sb=1.4e-07 sca=3.52678 scb=0.000111658 scc=3.66286e-09 fw=2.4e-07 $X=1140 $Y=510 $dt=0
.ends FlipFlop

* +++++++++++++++++++++++++++++++++++++++++++++++++++++++++ *
* Sub cell: NAND                                            *
* +++++++++++++++++++++++++++++++++++++++++++++++++++++++++ *
.subckt NAND 1 2 3 4 5 6
*.DEVICECLIMB
** N=6 EP=6 FDC=2
X0 2 M2_M1_CDNS_1 $T=-1740 -970 0 0 $X=-1820 $Y=-1100
X1 1 M2_M1_CDNS_1 $T=-1740 2330 0 0 $X=-1820 $Y=2200
X2 3 M2_M1_CDNS_1 $T=-1330 680 0 0 $X=-1410 $Y=550
X3 1 M2_M1_CDNS_1 $T=-490 2330 0 0 $X=-570 $Y=2200
X4 3 M2_M1_CDNS_1 $T=-80 680 0 0 $X=-160 $Y=550
X5 2 M2_M1_CDNS_2 $T=-1740 -260 0 0 $X=-1820 $Y=-530
X6 1 M2_M1_CDNS_2 $T=-1740 1620 0 0 $X=-1820 $Y=1350
X7 3 M2_M1_CDNS_2 $T=-1330 1620 0 0 $X=-1410 $Y=1350
X8 1 M2_M1_CDNS_2 $T=-490 1620 0 0 $X=-570 $Y=1350
X9 3 M2_M1_CDNS_2 $T=-80 -260 0 0 $X=-160 $Y=-530
X10 3 M2_M1_CDNS_2 $T=-80 1620 0 0 $X=-160 $Y=1350
X11 5 M1_PO_CDNS_4 $T=-1535 1050 0 0 $X=-1635 $Y=930
X12 4 M1_PO_CDNS_4 $T=-285 310 0 0 $X=-385 $Y=190
X13 1 M1_NWELL_CDNS_5 $T=-970 2380 0 0 $X=-1270 $Y=2000
X14 2 M1_PSUB_CDNS_6 $T=-870 -960 0 0 $X=-1130 $Y=-1240
X15 2 5 6 2 nmos1v_CDNS_8 $T=-1580 -500 0 0 $X=-2000 $Y=-700
X16 6 4 3 2 nmos1v_CDNS_8 $T=-330 -500 0 0 $X=-750 $Y=-700
X17 1 5 3 2 pmos1v_CDNS_10 $T=-1580 1380 0 0 $X=-2000 $Y=1180
X18 1 4 3 2 pmos1v_CDNS_10 $T=-330 1380 0 0 $X=-750 $Y=1180
M0 6 5 2 2 g45n1svt w=2.4e-07 l=4.5e-08 ad=3.36e-14 as=3.36e-14 pd=7.6e-07 ps=7.6e-07 sa=1.4e-07 sb=1.4e-07 sca=3.52678 scb=0.000111658 scc=3.66286e-09 fw=2.4e-07 $X=-1580 $Y=-500 $dt=0
M1 3 4 6 2 g45n1svt w=2.4e-07 l=4.5e-08 ad=3.36e-14 as=3.36e-14 pd=7.6e-07 ps=7.6e-07 sa=1.4e-07 sb=1.4e-07 sca=3.52678 scb=0.000111658 scc=3.66286e-09 fw=2.4e-07 $X=-330 $Y=-500 $dt=0
.ends NAND

* +++++++++++++++++++++++++++++++++++++++++++++++++++++++++ *
* Sub cell: XOR                                             *
* +++++++++++++++++++++++++++++++++++++++++++++++++++++++++ *
.subckt XOR 1 2 3 4 5 6 7 8 9 10
+ 11
*.DEVICECLIMB
** N=11 EP=11 FDC=8
X0 1 M2_M1_CDNS_1 $T=-2720 2750 0 0 $X=-2800 $Y=2620
X1 1 M2_M1_CDNS_1 $T=-2720 6460 0 0 $X=-2800 $Y=6330
X2 2 M2_M1_CDNS_1 $T=-2380 2040 0 0 $X=-2460 $Y=1910
X3 2 M2_M1_CDNS_1 $T=-2380 5900 0 0 $X=-2460 $Y=5770
X4 3 M2_M1_CDNS_1 $T=-1770 60 0 0 $X=-1850 $Y=-70
X5 4 M2_M1_CDNS_1 $T=-1760 4560 0 0 $X=-1840 $Y=4430
X6 3 M2_M1_CDNS_1 $T=-1760 7650 0 0 $X=-1840 $Y=7520
X7 1 M2_M1_CDNS_1 $T=-850 1410 0 0 $X=-930 $Y=1280
X8 1 M2_M1_CDNS_1 $T=-850 2740 0 0 $X=-930 $Y=2610
X9 5 M2_M1_CDNS_1 $T=60 2700 0 0 $X=-20 $Y=2570
X10 6 M2_M1_CDNS_1 $T=540 1730 0 0 $X=460 $Y=1600
X11 6 M2_M1_CDNS_1 $T=540 2380 0 0 $X=460 $Y=2250
X12 3 M2_M1_CDNS_1 $T=1030 50 0 0 $X=950 $Y=-80
X13 4 M2_M1_CDNS_1 $T=1030 4570 0 0 $X=950 $Y=4440
X14 4 M2_M1_CDNS_1 $T=1900 4560 0 0 $X=1820 $Y=4430
X15 3 M2_M1_CDNS_1 $T=1900 7650 0 0 $X=1820 $Y=7520
X16 6 M2_M1_CDNS_1 $T=2310 5970 0 0 $X=2230 $Y=5840
X17 5 M2_M1_CDNS_1 $T=2810 2700 0 0 $X=2730 $Y=2570
X18 3 M2_M1_CDNS_1 $T=3240 60 0 0 $X=3160 $Y=-70
X19 3 M2_M1_CDNS_1 $T=3240 7620 0 0 $X=3160 $Y=7490
X20 3 M2_M1_CDNS_2 $T=-1770 850 0 0 $X=-1850 $Y=580
X21 4 M2_M1_CDNS_2 $T=-1760 5340 0 0 $X=-1840 $Y=5070
X22 3 M2_M1_CDNS_2 $T=-1760 6980 0 0 $X=-1840 $Y=6710
X23 7 M2_M1_CDNS_2 $T=-1350 5340 0 0 $X=-1430 $Y=5070
X24 7 M2_M1_CDNS_2 $T=-1350 6980 0 0 $X=-1430 $Y=6710
X25 5 M2_M1_CDNS_2 $T=60 850 0 0 $X=-20 $Y=580
X26 3 M2_M1_CDNS_2 $T=1030 850 0 0 $X=950 $Y=580
X27 4 M2_M1_CDNS_2 $T=1900 5340 0 0 $X=1820 $Y=5070
X28 3 M2_M1_CDNS_2 $T=1900 6980 0 0 $X=1820 $Y=6710
X29 6 M2_M1_CDNS_2 $T=2310 5340 0 0 $X=2230 $Y=5070
X30 6 M2_M1_CDNS_2 $T=2310 6980 0 0 $X=2230 $Y=6710
X31 5 M2_M1_CDNS_2 $T=2810 850 0 0 $X=2730 $Y=580
X32 4 M2_M1_CDNS_3 $T=-1770 3580 0 0 $X=-1850 $Y=3030
X33 5 M2_M1_CDNS_3 $T=60 3570 0 0 $X=-20 $Y=3020
X34 4 M2_M1_CDNS_3 $T=1030 3570 0 0 $X=950 $Y=3020
X35 5 M2_M1_CDNS_3 $T=2810 3560 0 0 $X=2730 $Y=3010
X36 6 M1_PO_CDNS_4 $T=-1565 1720 0 0 $X=-1665 $Y=1600
X37 1 M1_PO_CDNS_4 $T=-1565 2750 0 0 $X=-1665 $Y=2630
X38 2 M1_PO_CDNS_4 $T=-1555 5900 0 0 $X=-1655 $Y=5780
X39 7 M1_PO_CDNS_4 $T=-145 5330 0 0 $X=-245 $Y=5210
X40 6 M1_PO_CDNS_4 $T=1235 2390 0 0 $X=1135 $Y=2270
X41 6 M1_PO_CDNS_4 $T=1235 5970 0 0 $X=1135 $Y=5850
X42 1 M1_PO_CDNS_4 $T=1240 1420 0 0 $X=1140 $Y=1300
X43 1 M1_PO_CDNS_4 $T=2100 6465 0 0 $X=2000 $Y=6345
X44 2 M1_PO_CDNS_4 $T=2600 2035 0 0 $X=2500 $Y=1915
X45 4 M1_NWELL_CDNS_5 $T=520 4590 0 0 $X=220 $Y=4210
X46 3 M1_PSUB_CDNS_6 $T=490 7650 0 0 $X=230 $Y=7370
X47 3 M1_PSUB_CDNS_6 $T=520 70 0 0 $X=260 $Y=-210
X48 4 8 1 3 4 pmos1v_CDNS_7 $T=-1610 3090 0 0 $X=-2030 $Y=2890
X49 8 5 7 3 4 pmos1v_CDNS_7 $T=-190 3090 0 0 $X=-610 $Y=2890
X50 4 9 6 3 4 pmos1v_CDNS_7 $T=1190 3090 0 0 $X=770 $Y=2890
X51 9 5 2 3 4 pmos1v_CDNS_7 $T=2560 3090 0 0 $X=2140 $Y=2890
X52 3 6 10 3 nmos1v_CDNS_8 $T=-1610 610 0 0 $X=-2030 $Y=410
X53 10 7 5 3 nmos1v_CDNS_8 $T=-190 610 0 0 $X=-610 $Y=410
X54 3 1 11 3 nmos1v_CDNS_8 $T=1190 610 0 0 $X=770 $Y=410
X55 11 2 5 3 nmos1v_CDNS_8 $T=2560 610 0 0 $X=2140 $Y=410
X56 3 7 2 nmos1v_CDNS_9 $T=-1600 6860 0 0 $X=-2020 $Y=6660
X57 3 6 1 nmos1v_CDNS_9 $T=2060 6860 0 0 $X=1640 $Y=6660
X58 4 2 7 3 pmos1v_CDNS_10 $T=-1600 5100 0 0 $X=-2020 $Y=4900
X59 4 1 6 3 pmos1v_CDNS_10 $T=2060 5100 0 0 $X=1640 $Y=4900
M0 10 6 3 3 g45n1svt w=2.4e-07 l=4.5e-08 ad=3.36e-14 as=3.36e-14 pd=7.6e-07 ps=7.6e-07 sa=1.4e-07 sb=1.4e-07 sca=3.52678 scb=0.000111658 scc=3.66286e-09 fw=2.4e-07 $X=-1610 $Y=610 $dt=0
M1 5 7 10 3 g45n1svt w=2.4e-07 l=4.5e-08 ad=3.36e-14 as=3.36e-14 pd=7.6e-07 ps=7.6e-07 sa=1.4e-07 sb=1.4e-07 sca=3.52678 scb=0.000111658 scc=3.66286e-09 fw=2.4e-07 $X=-190 $Y=610 $dt=0
M2 11 1 3 3 g45n1svt w=2.4e-07 l=4.5e-08 ad=3.36e-14 as=3.36e-14 pd=7.6e-07 ps=7.6e-07 sa=1.4e-07 sb=1.4e-07 sca=3.52678 scb=0.000111658 scc=3.66286e-09 fw=2.4e-07 $X=1190 $Y=610 $dt=0
M3 5 2 11 3 g45n1svt w=2.4e-07 l=4.5e-08 ad=3.36e-14 as=3.36e-14 pd=7.6e-07 ps=7.6e-07 sa=1.4e-07 sb=1.4e-07 sca=3.52678 scb=0.000111658 scc=3.66286e-09 fw=2.4e-07 $X=2560 $Y=610 $dt=0
M4 5 7 8 4 g45p1svt w=4.8e-07 l=4.5e-08 ad=6.72e-14 as=6.72e-14 pd=1.24e-06 ps=1.24e-06 sa=1.4e-07 sb=1.4e-07 sca=9.47395 scb=0.00759651 scc=0.000374483 fw=4.8e-07 $X=-190 $Y=3090 $dt=1
M5 9 6 4 4 g45p1svt w=4.8e-07 l=4.5e-08 ad=6.72e-14 as=6.72e-14 pd=1.24e-06 ps=1.24e-06 sa=1.4e-07 sb=1.4e-07 sca=9.47395 scb=0.00759651 scc=0.000374483 fw=4.8e-07 $X=1190 $Y=3090 $dt=1
.ends XOR

* +++++++++++++++++++++++++++++++++++++++++++++++++++++++++ *
* Sub cell: Full_Adder                                      *
* +++++++++++++++++++++++++++++++++++++++++++++++++++++++++ *
.subckt Full_Adder 1 2 3 4 5 6 7 8 9 10
+ 12 13 22 25
*.DEVICECLIMB
** N=25 EP=14 FDC=26
X0 1 M2_M1_CDNS_1 $T=-9300 1470 0 0 $X=-9380 $Y=1340
X1 2 M2_M1_CDNS_1 $T=-8960 730 0 0 $X=-9040 $Y=600
X2 5 M2_M1_CDNS_1 $T=-6260 2080 0 0 $X=-6340 $Y=1950
X3 5 M2_M1_CDNS_1 $T=-6260 3400 0 0 $X=-6340 $Y=3270
X4 8 M2_M1_CDNS_1 $T=-5830 1100 0 0 $X=-5910 $Y=970
X5 8 M2_M1_CDNS_1 $T=-5830 3270 0 0 $X=-5910 $Y=3140
X6 9 M2_M1_CDNS_1 $T=-2940 1470 0 0 $X=-3020 $Y=1340
X7 9 M2_M1_CDNS_1 $T=-2940 6230 0 0 $X=-3020 $Y=6100
X8 9 M2_M1_CDNS_1 $T=-2940 6890 0 0 $X=-3020 $Y=6760
X9 5 M2_M1_CDNS_1 $T=-2490 740 0 0 $X=-2570 $Y=610
X10 5 M2_M1_CDNS_1 $T=-2490 2080 0 0 $X=-2570 $Y=1950
X11 3 M2_M1_CDNS_1 $T=-1850 8710 0 0 $X=-1930 $Y=8580
X12 8 M2_M1_CDNS_1 $T=610 740 0 0 $X=530 $Y=610
X13 8 M2_M1_CDNS_1 $T=610 3270 0 0 $X=530 $Y=3140
X14 4 M2_M1_CDNS_1 $T=3470 -540 0 0 $X=3390 $Y=-670
X15 10 M2_M1_CDNS_2 $T=220 1290 0 0 $X=140 $Y=1020
X16 1 2 4 3 9 11 12 22 23 16
+ 17 XOR $T=-6580 4190 0 0 $X=-9990 $Y=3980
X17 5 9 4 3 6 13 14 24 25 19
+ 20 XOR $T=230 4190 0 0 $X=-3180 $Y=3980
X18 3 4 8 2 1 15 NAND $T=-6740 420 0 0 $X=-9060 $Y=-820
X19 3 4 10 5 9 18 NAND $T=-120 420 0 0 $X=-2440 $Y=-820
X20 3 4 7 8 10 21 NAND $T=3090 420 0 0 $X=770 $Y=-820
M0 11 1 3 3 g45p1svt w=2.4e-07 l=4.5e-08 ad=3.36e-14 as=3.36e-14 pd=7.6e-07 ps=7.6e-07 sa=1.4e-07 sb=1.4e-07 sca=34.1422 scb=0.0251568 scc=0.00441949 fw=2.4e-07 $X=-4520 $Y=9290 $dt=1
M1 9 2 23 3 g45p1svt w=4.8e-07 l=4.5e-08 ad=6.72e-14 as=6.72e-14 pd=1.24e-06 ps=1.24e-06 sa=1.4e-07 sb=1.4e-07 sca=9.47395 scb=0.00759651 scc=0.000374483 fw=4.8e-07 $X=-4020 $Y=7280 $dt=1
M2 24 5 3 3 g45p1svt w=4.8e-07 l=4.5e-08 ad=6.72e-14 as=6.72e-14 pd=1.24e-06 ps=1.24e-06 sa=1.4e-07 sb=1.4e-07 sca=9.47395 scb=0.00759651 scc=0.000374483 fw=4.8e-07 $X=-1380 $Y=7280 $dt=1
M3 14 9 3 3 g45p1svt w=2.4e-07 l=4.5e-08 ad=3.36e-14 as=3.36e-14 pd=7.6e-07 ps=7.6e-07 sa=1.4e-07 sb=1.4e-07 sca=34.1422 scb=0.0251568 scc=0.00441949 fw=2.4e-07 $X=-1370 $Y=9290 $dt=1
.ends Full_Adder

* +++++++++++++++++++++++++++++++++++++++++++++++++++++++++ *
* Sub cell: inv                                             *
* +++++++++++++++++++++++++++++++++++++++++++++++++++++++++ *
.subckt inv 1 2 3 4
** N=4 EP=4 FDC=2
X0 2 M2_M1_CDNS_1 $T=-250 -340 0 0 $X=-330 $Y=-470
X1 1 M2_M1_CDNS_1 $T=-250 2700 0 0 $X=-330 $Y=2570
X2 4 M2_M1_CDNS_1 $T=160 790 0 0 $X=80 $Y=660
X3 2 M2_M1_CDNS_2 $T=-250 255 0 0 $X=-330 $Y=-15
X4 1 M2_M1_CDNS_2 $T=-250 1860 0 0 $X=-330 $Y=1590
X5 4 M2_M1_CDNS_2 $T=160 255 0 0 $X=80 $Y=-15
X6 4 M2_M1_CDNS_2 $T=160 1860 0 0 $X=80 $Y=1590
X7 3 M1_PO_CDNS_4 $T=-40 1260 0 0 $X=-140 $Y=1140
X8 1 M1_NWELL_CDNS_5 $T=700 2720 0 0 $X=400 $Y=2340
X9 2 M1_PSUB_CDNS_6 $T=790 -400 0 0 $X=530 $Y=-680
X10 2 4 3 nmos1v_CDNS_9 $T=-90 135 0 0 $X=-510 $Y=-65
X11 1 3 4 2 pmos1v_CDNS_10 $T=-90 1620 0 0 $X=-510 $Y=1420
M0 4 3 1 1 g45p1svt w=2.4e-07 l=4.5e-08 ad=3.36e-14 as=3.36e-14 pd=7.6e-07 ps=7.6e-07 sa=1.4e-07 sb=1.4e-07 sca=27.9284 scb=0.0232624 scc=0.00337691 fw=2.4e-07 $X=-90 $Y=1620 $dt=1
.ends inv

* +++++++++++++++++++++++++++++++++++++++++++++++++++++++++ *
* Sub cell: faabs                                           *
* +++++++++++++++++++++++++++++++++++++++++++++++++++++++++ *
.subckt faabs 1 2 3 4 5 6 7 8 9 10
+ 11 12 14 19 20 31 36
*.DEVICECLIMB
** N=36 EP=17 FDC=48
X0 3 M2_M1_CDNS_1 $T=-12470 -460 0 0 $X=-12550 $Y=-590
X1 2 M2_M1_CDNS_1 $T=-12470 4000 0 0 $X=-12550 $Y=3870
X2 1 M2_M1_CDNS_1 $T=-11240 4320 0 0 $X=-11320 $Y=4190
X3 9 M2_M1_CDNS_1 $T=-40 1250 0 0 $X=-120 $Y=1120
X4 9 M2_M1_CDNS_1 $T=-40 7490 0 0 $X=-120 $Y=7360
X5 7 M2_M1_CDNS_1 $T=260 2010 0 0 $X=180 $Y=1880
X6 8 M2_M1_CDNS_1 $T=560 7540 0 0 $X=480 $Y=7410
X7 3 M2_M1_CDNS_1 $T=860 -460 0 0 $X=780 $Y=-590
X8 3 M2_M1_CDNS_1 $T=860 1650 0 0 $X=780 $Y=1520
X9 10 M2_M1_CDNS_1 $T=1160 3770 0 0 $X=1080 $Y=3640
X10 10 M2_M1_CDNS_1 $T=1160 6690 0 0 $X=1080 $Y=6560
X11 10 M2_M1_CDNS_1 $T=3790 1610 0 0 $X=3710 $Y=1480
X12 10 M2_M1_CDNS_1 $T=3790 3770 0 0 $X=3710 $Y=3640
X13 11 M2_M1_CDNS_1 $T=4720 1700 0 0 $X=4640 $Y=1570
X14 11 M2_M1_CDNS_1 $T=4720 3860 0 0 $X=4640 $Y=3730
X15 1 M2_M1_CDNS_1 $T=7360 1220 0 0 $X=7280 $Y=1090
X16 1 M2_M1_CDNS_1 $T=7360 4320 0 0 $X=7280 $Y=4190
X17 11 M2_M1_CDNS_1 $T=7660 3860 0 0 $X=7580 $Y=3730
X18 11 M2_M1_CDNS_1 $T=7660 7070 0 0 $X=7580 $Y=6940
X19 5 4 10 9 7 30 NAND $T=3320 930 0 0 $X=1000 $Y=-310
X20 1 6 5 4 2 9 3 19 15 18
+ 14 16 31 34 Full_Adder $T=-3810 600 0 0 $X=-13800 $Y=-220
X21 5 4 11 1 inv $T=6090 430 0 0 $X=4850 $Y=-250
X22 5 4 10 8 12 11 20 35 36 28
+ 29 FlipFlop $T=4300 4980 0 0 $X=890 $Y=4580
M0 11 8 29 4 g45n1svt w=2.4e-07 l=4.5e-08 ad=3.36e-14 as=3.36e-14 pd=7.6e-07 ps=7.6e-07 sa=1.4e-07 sb=1.4e-07 sca=3.52678 scb=0.000111658 scc=3.66286e-09 fw=2.4e-07 $X=6620 $Y=5490 $dt=0
M1 19 6 5 5 g45p1svt w=2.4e-07 l=4.5e-08 ad=3.36e-14 as=3.36e-14 pd=7.6e-07 ps=7.6e-07 sa=1.4e-07 sb=1.4e-07 sca=13.9617 scb=0.0132915 scc=0.000629907 fw=2.4e-07 $X=-10880 $Y=2400 $dt=1
M2 18 15 5 5 g45p1svt w=2.4e-07 l=4.5e-08 ad=3.36e-14 as=3.36e-14 pd=7.6e-07 ps=7.6e-07 sa=1.4e-07 sb=1.4e-07 sca=13.9617 scb=0.0132915 scc=0.000629907 fw=2.4e-07 $X=-5510 $Y=2400 $dt=1
M3 18 2 5 5 g45p1svt w=2.4e-07 l=4.5e-08 ad=3.36e-14 as=3.36e-14 pd=7.6e-07 ps=7.6e-07 sa=1.4e-07 sb=1.4e-07 sca=13.9617 scb=0.0132915 scc=0.000629907 fw=2.4e-07 $X=-4260 $Y=2400 $dt=1
M4 3 18 5 5 g45p1svt w=2.4e-07 l=4.5e-08 ad=3.36e-14 as=3.36e-14 pd=7.6e-07 ps=7.6e-07 sa=1.4e-07 sb=1.4e-07 sca=13.9617 scb=0.0132915 scc=0.000629907 fw=2.4e-07 $X=-2300 $Y=2400 $dt=1
M5 16 2 5 5 g45p1svt w=2.4e-07 l=4.5e-08 ad=3.36e-14 as=3.36e-14 pd=7.6e-07 ps=7.6e-07 sa=1.4e-07 sb=1.4e-07 sca=34.1422 scb=0.0251568 scc=0.00441949 fw=2.4e-07 $X=-1520 $Y=9890 $dt=1
M6 3 19 5 5 g45p1svt w=2.4e-07 l=4.5e-08 ad=3.36e-14 as=3.36e-14 pd=7.6e-07 ps=7.6e-07 sa=1.4e-07 sb=1.4e-07 sca=13.9617 scb=0.0132915 scc=0.000629907 fw=2.4e-07 $X=-1050 $Y=2400 $dt=1
M7 9 15 34 5 g45p1svt w=4.8e-07 l=4.5e-08 ad=6.72e-14 as=6.72e-14 pd=1.24e-06 ps=1.24e-06 sa=1.4e-07 sb=1.4e-07 sca=9.47395 scb=0.00759651 scc=0.000374483 fw=4.8e-07 $X=-1020 $Y=7880 $dt=1
M8 10 7 5 5 g45p1svt w=2.4e-07 l=4.5e-08 ad=3.36e-14 as=3.36e-14 pd=7.6e-07 ps=7.6e-07 sa=1.4e-07 sb=1.4e-07 sca=17.3073 scb=0.0169295 scc=0.00128868 fw=2.4e-07 $X=1740 $Y=2310 $dt=1
M9 20 8 5 5 g45p1svt w=2.4e-07 l=4.5e-08 ad=3.36e-14 as=3.36e-14 pd=7.6e-07 ps=7.6e-07 sa=1.4e-07 sb=1.4e-07 sca=10.0441 scb=0.00891249 scc=0.000296773 fw=2.4e-07 $X=1800 $Y=8140 $dt=1
M10 10 9 5 5 g45p1svt w=2.4e-07 l=4.5e-08 ad=3.36e-14 as=3.36e-14 pd=7.6e-07 ps=7.6e-07 sa=1.4e-07 sb=1.4e-07 sca=17.3073 scb=0.0169295 scc=0.00128868 fw=2.4e-07 $X=2990 $Y=2310 $dt=1
M11 35 10 5 5 g45p1svt w=4.8e-07 l=4.5e-08 ad=6.72e-14 as=6.72e-14 pd=1.24e-06 ps=1.24e-06 sa=1.4e-07 sb=1.4e-07 sca=13.8415 scb=0.0117975 scc=0.0011174 fw=4.8e-07 $X=3040 $Y=7890 $dt=1
M12 12 8 35 5 g45p1svt w=4.8e-07 l=4.5e-08 ad=6.72e-14 as=6.72e-14 pd=1.24e-06 ps=1.24e-06 sa=1.4e-07 sb=1.4e-07 sca=13.3978 scb=0.0114602 scc=0.001037 fw=4.8e-07 $X=4250 $Y=7900 $dt=1
M13 36 12 5 5 g45p1svt w=4.8e-07 l=4.5e-08 ad=6.72e-14 as=6.72e-14 pd=1.24e-06 ps=1.24e-06 sa=1.4e-07 sb=1.4e-07 sca=13.8415 scb=0.0117975 scc=0.0011174 fw=4.8e-07 $X=5440 $Y=7890 $dt=1
.ends faabs

* +++++++++++++++++++++++++++++++++++++++++++++++++++++++++ *
* Sub cell: AND                                             *
* +++++++++++++++++++++++++++++++++++++++++++++++++++++++++ *
.subckt AND 1 2 3 4 5 6 7
*.DEVICECLIMB
** N=7 EP=7 FDC=4
X0 2 M2_M1_CDNS_1 $T=-2270 400 0 0 $X=-2350 $Y=270
X1 1 M2_M1_CDNS_1 $T=-2270 3710 0 0 $X=-2350 $Y=3580
X2 6 M2_M1_CDNS_1 $T=-1860 2090 0 0 $X=-1940 $Y=1960
X3 1 M2_M1_CDNS_1 $T=-990 3710 0 0 $X=-1070 $Y=3580
X4 6 M2_M1_CDNS_1 $T=-580 2090 0 0 $X=-660 $Y=1960
X5 2 M2_M1_CDNS_1 $T=260 450 0 0 $X=180 $Y=320
X6 1 M2_M1_CDNS_1 $T=260 3710 0 0 $X=180 $Y=3580
X7 5 M2_M1_CDNS_1 $T=670 1690 0 0 $X=590 $Y=1560
X8 2 M2_M1_CDNS_2 $T=-2270 1160 0 0 $X=-2350 $Y=890
X9 1 M2_M1_CDNS_2 $T=-2270 3010 0 0 $X=-2350 $Y=2740
X10 6 M2_M1_CDNS_2 $T=-1860 3010 0 0 $X=-1940 $Y=2740
X11 1 M2_M1_CDNS_2 $T=-990 3010 0 0 $X=-1070 $Y=2740
X12 6 M2_M1_CDNS_2 $T=-580 1170 0 0 $X=-660 $Y=900
X13 6 M2_M1_CDNS_2 $T=-580 3010 0 0 $X=-660 $Y=2740
X14 2 M2_M1_CDNS_2 $T=260 1140 0 0 $X=180 $Y=870
X15 1 M2_M1_CDNS_2 $T=260 3010 0 0 $X=180 $Y=2740
X16 5 M2_M1_CDNS_2 $T=670 1140 0 0 $X=590 $Y=870
X17 5 M2_M1_CDNS_2 $T=670 3010 0 0 $X=590 $Y=2740
X18 4 M1_PO_CDNS_4 $T=-2060 2460 0 0 $X=-2160 $Y=2340
X19 3 M1_PO_CDNS_4 $T=-790 1720 0 0 $X=-890 $Y=1600
X20 6 M1_PO_CDNS_4 $T=460 2090 0 0 $X=360 $Y=1970
X21 1 M1_NWELL_CDNS_5 $T=-1460 3780 0 0 $X=-1760 $Y=3400
X22 2 M1_PSUB_CDNS_6 $T=-1420 430 0 0 $X=-1680 $Y=150
X23 2 4 7 2 nmos1v_CDNS_8 $T=-2110 920 0 0 $X=-2530 $Y=720
X24 7 3 6 2 nmos1v_CDNS_8 $T=-830 920 0 0 $X=-1250 $Y=720
X25 2 5 6 nmos1v_CDNS_9 $T=420 1020 0 0 $X=0 $Y=820
X26 1 4 6 2 pmos1v_CDNS_10 $T=-2110 2770 0 0 $X=-2530 $Y=2570
X27 1 3 6 2 pmos1v_CDNS_10 $T=-830 2770 0 0 $X=-1250 $Y=2570
X28 1 6 5 2 pmos1v_CDNS_10 $T=420 2770 0 0 $X=0 $Y=2570
M0 7 4 2 2 g45n1svt w=2.4e-07 l=4.5e-08 ad=3.36e-14 as=3.36e-14 pd=7.6e-07 ps=7.6e-07 sa=1.4e-07 sb=1.4e-07 sca=3.52678 scb=0.000111658 scc=3.66286e-09 fw=2.4e-07 $X=-2110 $Y=920 $dt=0
M1 6 3 7 2 g45n1svt w=2.4e-07 l=4.5e-08 ad=3.36e-14 as=3.36e-14 pd=7.6e-07 ps=7.6e-07 sa=1.4e-07 sb=1.4e-07 sca=3.52678 scb=0.000111658 scc=3.66286e-09 fw=2.4e-07 $X=-830 $Y=920 $dt=0
M2 6 3 1 1 g45p1svt w=2.4e-07 l=4.5e-08 ad=3.36e-14 as=3.36e-14 pd=7.6e-07 ps=7.6e-07 sa=1.4e-07 sb=1.4e-07 sca=12.8329 scb=0.0117498 scc=0.000390557 fw=2.4e-07 $X=-830 $Y=2770 $dt=1
.ends AND

* +++++++++++++++++++++++++++++++++++++++++++++++++++++++++ *
* Sub cell: Half_Adder                                      *
* +++++++++++++++++++++++++++++++++++++++++++++++++++++++++ *
.subckt Half_Adder 1 2 3 4 5 6 7 8 9 10
+ 11 12 13
*.DEVICECLIMB
** N=13 EP=13 FDC=15
X0 1 M2_M1_CDNS_1 $T=-3270 -790 0 0 $X=-3350 $Y=-920
X1 1 M2_M1_CDNS_1 $T=-3270 3580 0 0 $X=-3350 $Y=3450
X2 2 M2_M1_CDNS_1 $T=-2930 -1500 0 0 $X=-3010 $Y=-1630
X3 2 M2_M1_CDNS_1 $T=-2930 2360 0 0 $X=-3010 $Y=2230
X4 3 M2_M1_CDNS_1 $T=-2320 -3480 0 0 $X=-2400 $Y=-3610
X5 4 M2_M1_CDNS_1 $T=-2310 1020 0 0 $X=-2390 $Y=890
X6 3 M2_M1_CDNS_1 $T=-2310 4770 0 0 $X=-2390 $Y=4640
X7 7 M2_M1_CDNS_1 $T=-1900 2810 0 0 $X=-1980 $Y=2680
X8 1 M2_M1_CDNS_1 $T=-1400 -2130 0 0 $X=-1480 $Y=-2260
X9 1 M2_M1_CDNS_1 $T=-1400 -800 0 0 $X=-1480 $Y=-930
X10 5 M2_M1_CDNS_1 $T=-490 -840 0 0 $X=-570 $Y=-970
X11 8 M2_M1_CDNS_1 $T=-10 -1810 0 0 $X=-90 $Y=-1940
X12 8 M2_M1_CDNS_1 $T=-10 -1160 0 0 $X=-90 $Y=-1290
X13 3 M2_M1_CDNS_1 $T=480 -3490 0 0 $X=400 $Y=-3620
X14 4 M2_M1_CDNS_1 $T=480 1030 0 0 $X=400 $Y=900
X15 4 M2_M1_CDNS_1 $T=1350 1020 0 0 $X=1270 $Y=890
X16 3 M2_M1_CDNS_1 $T=1350 4770 0 0 $X=1270 $Y=4640
X17 8 M2_M1_CDNS_1 $T=1760 2430 0 0 $X=1680 $Y=2300
X18 8 M2_M1_CDNS_1 $T=1760 3210 0 0 $X=1680 $Y=3080
X19 5 M2_M1_CDNS_1 $T=2260 -840 0 0 $X=2180 $Y=-970
X20 4 M2_M1_CDNS_1 $T=2890 1050 0 0 $X=2810 $Y=920
X21 3 M2_M1_CDNS_1 $T=2890 4840 0 0 $X=2810 $Y=4710
X22 6 M2_M1_CDNS_1 $T=3300 3580 0 0 $X=3220 $Y=3450
X23 3 M2_M1_CDNS_1 $T=4230 4840 0 0 $X=4150 $Y=4710
X24 6 M2_M1_CDNS_1 $T=4640 3580 0 0 $X=4560 $Y=3450
X25 3 M2_M1_CDNS_1 $T=5320 -3480 0 0 $X=5240 $Y=-3610
X26 3 M2_M1_CDNS_1 $T=5320 4820 0 0 $X=5240 $Y=4690
X27 3 M2_M1_CDNS_2 $T=-2320 -2690 0 0 $X=-2400 $Y=-2960
X28 4 M2_M1_CDNS_2 $T=-2310 1800 0 0 $X=-2390 $Y=1530
X29 3 M2_M1_CDNS_2 $T=-2310 4100 0 0 $X=-2390 $Y=3830
X30 7 M2_M1_CDNS_2 $T=-1900 1800 0 0 $X=-1980 $Y=1530
X31 7 M2_M1_CDNS_2 $T=-1900 4100 0 0 $X=-1980 $Y=3830
X32 5 M2_M1_CDNS_2 $T=-490 -2690 0 0 $X=-570 $Y=-2960
X33 3 M2_M1_CDNS_2 $T=480 -2690 0 0 $X=400 $Y=-2960
X34 4 M2_M1_CDNS_2 $T=1350 1800 0 0 $X=1270 $Y=1530
X35 3 M2_M1_CDNS_2 $T=1350 4100 0 0 $X=1270 $Y=3830
X36 8 M2_M1_CDNS_2 $T=1760 1800 0 0 $X=1680 $Y=1530
X37 8 M2_M1_CDNS_2 $T=1760 4100 0 0 $X=1680 $Y=3830
X38 5 M2_M1_CDNS_2 $T=2260 -2690 0 0 $X=2180 $Y=-2960
X39 3 M2_M1_CDNS_2 $T=2890 4110 0 0 $X=2810 $Y=3840
X40 6 M2_M1_CDNS_2 $T=3300 4110 0 0 $X=3220 $Y=3840
X41 3 M2_M1_CDNS_2 $T=4230 4110 0 0 $X=4150 $Y=3840
X42 6 M2_M1_CDNS_2 $T=4640 4110 0 0 $X=4560 $Y=3840
X43 4 M2_M1_CDNS_3 $T=-2320 40 0 0 $X=-2400 $Y=-510
X44 5 M2_M1_CDNS_3 $T=-490 30 0 0 $X=-570 $Y=-520
X45 4 M2_M1_CDNS_3 $T=480 30 0 0 $X=400 $Y=-520
X46 5 M2_M1_CDNS_3 $T=2260 20 0 0 $X=2180 $Y=-530
X47 4 M2_M1_CDNS_3 $T=2890 1960 0 0 $X=2810 $Y=1410
X48 6 M2_M1_CDNS_3 $T=4640 1960 0 0 $X=4560 $Y=1410
X49 8 M1_PO_CDNS_4 $T=-2115 -1820 0 0 $X=-2215 $Y=-1940
X50 1 M1_PO_CDNS_4 $T=-2115 -790 0 0 $X=-2215 $Y=-910
X51 2 M1_PO_CDNS_4 $T=-2105 2360 0 0 $X=-2205 $Y=2240
X52 7 M1_PO_CDNS_4 $T=-695 1790 0 0 $X=-795 $Y=1670
X53 8 M1_PO_CDNS_4 $T=685 -1150 0 0 $X=585 $Y=-1270
X54 8 M1_PO_CDNS_4 $T=685 2430 0 0 $X=585 $Y=2310
X55 1 M1_PO_CDNS_4 $T=690 -2120 0 0 $X=590 $Y=-2240
X56 1 M1_PO_CDNS_4 $T=1550 3585 0 0 $X=1450 $Y=3465
X57 2 M1_PO_CDNS_4 $T=2050 -1505 0 0 $X=1950 $Y=-1625
X58 8 M1_PO_CDNS_4 $T=3090 3210 0 0 $X=2990 $Y=3090
X59 7 M1_PO_CDNS_4 $T=4430 2820 0 0 $X=4330 $Y=2700
X60 4 M1_NWELL_CDNS_5 $T=-30 1050 0 0 $X=-330 $Y=670
X61 3 M1_PSUB_CDNS_6 $T=-60 4770 0 0 $X=-320 $Y=4490
X62 3 M1_PSUB_CDNS_6 $T=-30 -3470 0 0 $X=-290 $Y=-3750
X63 4 9 1 3 4 pmos1v_CDNS_7 $T=-2160 -450 0 0 $X=-2580 $Y=-650
X64 9 5 7 3 4 pmos1v_CDNS_7 $T=-740 -450 0 0 $X=-1160 $Y=-650
X65 4 10 8 3 4 pmos1v_CDNS_7 $T=640 -450 0 0 $X=220 $Y=-650
X66 10 5 2 3 4 pmos1v_CDNS_7 $T=2010 -450 0 0 $X=1590 $Y=-650
X67 4 11 8 3 4 pmos1v_CDNS_7 $T=3050 1480 0 0 $X=2630 $Y=1280
X68 11 6 7 3 4 pmos1v_CDNS_7 $T=4390 1480 0 0 $X=3970 $Y=1280
X69 3 8 12 3 nmos1v_CDNS_8 $T=-2160 -2930 0 0 $X=-2580 $Y=-3130
X70 12 7 5 3 nmos1v_CDNS_8 $T=-740 -2930 0 0 $X=-1160 $Y=-3130
X71 3 1 13 3 nmos1v_CDNS_8 $T=640 -2930 0 0 $X=220 $Y=-3130
X72 13 2 5 3 nmos1v_CDNS_8 $T=2010 -2930 0 0 $X=1590 $Y=-3130
X73 3 7 2 nmos1v_CDNS_9 $T=-2150 3980 0 0 $X=-2570 $Y=3780
X74 3 8 1 nmos1v_CDNS_9 $T=1510 3980 0 0 $X=1090 $Y=3780
X75 3 6 8 nmos1v_CDNS_9 $T=3050 3980 0 0 $X=2630 $Y=3780
X76 3 6 7 nmos1v_CDNS_9 $T=4390 3980 0 0 $X=3970 $Y=3780
X77 4 2 7 3 pmos1v_CDNS_10 $T=-2150 1560 0 0 $X=-2570 $Y=1360
X78 4 1 8 3 pmos1v_CDNS_10 $T=1510 1560 0 0 $X=1090 $Y=1360
M0 12 8 3 3 g45n1svt w=2.4e-07 l=4.5e-08 ad=3.36e-14 as=3.36e-14 pd=7.6e-07 ps=7.6e-07 sa=1.4e-07 sb=1.4e-07 sca=3.52678 scb=0.000111658 scc=3.66286e-09 fw=2.4e-07 $X=-2160 $Y=-2930 $dt=0
M1 5 7 12 3 g45n1svt w=2.4e-07 l=4.5e-08 ad=3.36e-14 as=3.36e-14 pd=7.6e-07 ps=7.6e-07 sa=1.4e-07 sb=1.4e-07 sca=3.52678 scb=0.000111658 scc=3.66286e-09 fw=2.4e-07 $X=-740 $Y=-2930 $dt=0
M2 13 1 3 3 g45n1svt w=2.4e-07 l=4.5e-08 ad=3.36e-14 as=3.36e-14 pd=7.6e-07 ps=7.6e-07 sa=1.4e-07 sb=1.4e-07 sca=3.52678 scb=0.000111658 scc=3.66286e-09 fw=2.4e-07 $X=640 $Y=-2930 $dt=0
M3 5 2 13 3 g45n1svt w=2.4e-07 l=4.5e-08 ad=3.36e-14 as=3.36e-14 pd=7.6e-07 ps=7.6e-07 sa=1.4e-07 sb=1.4e-07 sca=3.52678 scb=0.000111658 scc=3.66286e-09 fw=2.4e-07 $X=2010 $Y=-2930 $dt=0
M4 9 1 4 4 g45p1svt w=4.8e-07 l=4.5e-08 ad=6.72e-14 as=6.72e-14 pd=1.24e-06 ps=1.24e-06 sa=1.4e-07 sb=1.4e-07 sca=7.67703 scb=0.00492794 scc=0.000127123 fw=4.8e-07 $X=-2160 $Y=-450 $dt=1
M5 7 2 4 4 g45p1svt w=2.4e-07 l=4.5e-08 ad=3.36e-14 as=3.36e-14 pd=7.6e-07 ps=7.6e-07 sa=1.4e-07 sb=1.4e-07 sca=6.19868 scb=0.00224643 scc=1.06334e-05 fw=2.4e-07 $X=-2150 $Y=1560 $dt=1
M6 5 7 9 4 g45p1svt w=4.8e-07 l=4.5e-08 ad=6.72e-14 as=6.72e-14 pd=1.24e-06 ps=1.24e-06 sa=1.4e-07 sb=1.4e-07 sca=7.2888 scb=0.00480939 scc=0.000127096 fw=4.8e-07 $X=-740 $Y=-450 $dt=1
M7 10 8 4 4 g45p1svt w=4.8e-07 l=4.5e-08 ad=6.72e-14 as=6.72e-14 pd=1.24e-06 ps=1.24e-06 sa=1.4e-07 sb=1.4e-07 sca=7.2888 scb=0.00480939 scc=0.000127096 fw=4.8e-07 $X=640 $Y=-450 $dt=1
M8 8 1 4 4 g45p1svt w=2.4e-07 l=4.5e-08 ad=3.36e-14 as=3.36e-14 pd=7.6e-07 ps=7.6e-07 sa=1.4e-07 sb=1.4e-07 sca=5.82592 scb=0.00213462 scc=1.06087e-05 fw=2.4e-07 $X=1510 $Y=1560 $dt=1
M9 5 2 10 4 g45p1svt w=4.8e-07 l=4.5e-08 ad=6.72e-14 as=6.72e-14 pd=1.24e-06 ps=1.24e-06 sa=1.4e-07 sb=1.4e-07 sca=7.2888 scb=0.00480939 scc=0.000127096 fw=4.8e-07 $X=2010 $Y=-450 $dt=1
M10 11 8 4 4 g45p1svt w=4.8e-07 l=4.5e-08 ad=6.72e-14 as=6.72e-14 pd=1.24e-06 ps=1.24e-06 sa=1.4e-07 sb=1.4e-07 sca=7.78706 scb=0.00554847 scc=0.000178111 fw=4.8e-07 $X=3050 $Y=1480 $dt=1
.ends Half_Adder

* +++++++++++++++++++++++++++++++++++++++++++++++++++++++++ *
* Sub cell: Multiplier                                      *
* +++++++++++++++++++++++++++++++++++++++++++++++++++++++++ *
.subckt Multiplier 1 2 3 4 5 6 7 8 9 10
+ 11 12 13 14 15 16 17 18 19 20
+ 21 22 23 24 25 26 27 28 29 30
+ 31 32 33 34 35 36 37 38 39 40
+ 41 42 43 44 45 46 47 48 49 50
+ 51 52
** N=268 EP=52 FDC=472
X0 1 M2_M1_CDNS_1 $T=7650 -28760 0 0 $X=7570 $Y=-28890
X1 1 M2_M1_CDNS_1 $T=7650 -4390 0 0 $X=7570 $Y=-4520
X2 1 M2_M1_CDNS_1 $T=7650 19940 0 0 $X=7570 $Y=19810
X3 1 M2_M1_CDNS_1 $T=7650 26060 0 0 $X=7570 $Y=25930
X4 2 M2_M1_CDNS_1 $T=7950 -28360 0 0 $X=7870 $Y=-28490
X5 2 M2_M1_CDNS_1 $T=7950 -3990 0 0 $X=7870 $Y=-4120
X6 2 M2_M1_CDNS_1 $T=7950 20340 0 0 $X=7870 $Y=20210
X7 2 M2_M1_CDNS_1 $T=7950 26460 0 0 $X=7870 $Y=26330
X8 3 M2_M1_CDNS_1 $T=8250 -27960 0 0 $X=8170 $Y=-28090
X9 3 M2_M1_CDNS_1 $T=8250 -3590 0 0 $X=8170 $Y=-3720
X10 3 M2_M1_CDNS_1 $T=8250 20740 0 0 $X=8170 $Y=20610
X11 3 M2_M1_CDNS_1 $T=8250 26860 0 0 $X=8170 $Y=26730
X12 4 M2_M1_CDNS_1 $T=8550 -27560 0 0 $X=8470 $Y=-27690
X13 4 M2_M1_CDNS_1 $T=8550 -3190 0 0 $X=8470 $Y=-3320
X14 4 M2_M1_CDNS_1 $T=8550 21140 0 0 $X=8470 $Y=21010
X15 4 M2_M1_CDNS_1 $T=8550 27260 0 0 $X=8470 $Y=27130
X16 1 M2_M1_CDNS_1 $T=8850 22990 0 0 $X=8770 $Y=22860
X17 1 M2_M1_CDNS_1 $T=8850 26060 0 0 $X=8770 $Y=25930
X18 5 M2_M1_CDNS_1 $T=9150 23730 0 0 $X=9070 $Y=23600
X19 5 M2_M1_CDNS_1 $T=9150 25660 0 0 $X=9070 $Y=25530
X20 19 M2_M1_CDNS_1 $T=9410 -33720 0 0 $X=9330 $Y=-33850
X21 20 M2_M1_CDNS_1 $T=9750 -34100 0 0 $X=9670 $Y=-34230
X22 1 M2_M1_CDNS_1 $T=10600 -7460 0 0 $X=10520 $Y=-7590
X23 1 M2_M1_CDNS_1 $T=10600 -4390 0 0 $X=10520 $Y=-4520
X24 1 M2_M1_CDNS_1 $T=10600 16870 0 0 $X=10520 $Y=16740
X25 1 M2_M1_CDNS_1 $T=10600 19940 0 0 $X=10520 $Y=19810
X26 21 M2_M1_CDNS_1 $T=10840 -9750 0 0 $X=10760 $Y=-9880
X27 22 M2_M1_CDNS_1 $T=10840 14580 0 0 $X=10760 $Y=14450
X28 7 M2_M1_CDNS_1 $T=10900 -6720 0 0 $X=10820 $Y=-6850
X29 7 M2_M1_CDNS_1 $T=10900 -4790 0 0 $X=10820 $Y=-4920
X30 6 M2_M1_CDNS_1 $T=10900 17610 0 0 $X=10820 $Y=17480
X31 6 M2_M1_CDNS_1 $T=10900 19540 0 0 $X=10820 $Y=19410
X32 23 M2_M1_CDNS_1 $T=11180 -10130 0 0 $X=11100 $Y=-10260
X33 24 M2_M1_CDNS_1 $T=11180 14200 0 0 $X=11100 $Y=14070
X34 1 M2_M1_CDNS_1 $T=11750 -31820 0 0 $X=11670 $Y=-31950
X35 1 M2_M1_CDNS_1 $T=11750 -28760 0 0 $X=11670 $Y=-28890
X36 8 M2_M1_CDNS_1 $T=12050 -31080 0 0 $X=11970 $Y=-31210
X37 8 M2_M1_CDNS_1 $T=12050 -29160 0 0 $X=11970 $Y=-29290
X38 9 M2_M1_CDNS_1 $T=13040 19850 0 0 $X=12960 $Y=19720
X39 9 M2_M1_CDNS_1 $T=13040 22950 0 0 $X=12960 $Y=22820
X40 20 M2_M1_CDNS_1 $T=14750 -34100 0 0 $X=14670 $Y=-34230
X41 20 M2_M1_CDNS_1 $T=14750 -26830 0 0 $X=14670 $Y=-26960
X42 23 M2_M1_CDNS_1 $T=14750 -10130 0 0 $X=14670 $Y=-10260
X43 23 M2_M1_CDNS_1 $T=14750 -2500 0 0 $X=14670 $Y=-2630
X44 19 M2_M1_CDNS_1 $T=15050 -33720 0 0 $X=14970 $Y=-33850
X45 19 M2_M1_CDNS_1 $T=15050 -31450 0 0 $X=14970 $Y=-31580
X46 21 M2_M1_CDNS_1 $T=15050 -9750 0 0 $X=14970 $Y=-9880
X47 21 M2_M1_CDNS_1 $T=15050 -7490 0 0 $X=14970 $Y=-7620
X48 22 M2_M1_CDNS_1 $T=15050 14580 0 0 $X=14970 $Y=14450
X49 22 M2_M1_CDNS_1 $T=15050 16840 0 0 $X=14970 $Y=16710
X50 2 M2_M1_CDNS_1 $T=15780 22990 0 0 $X=15700 $Y=22860
X51 2 M2_M1_CDNS_1 $T=15780 26460 0 0 $X=15700 $Y=26330
X52 5 M2_M1_CDNS_1 $T=16080 23730 0 0 $X=16000 $Y=23600
X53 5 M2_M1_CDNS_1 $T=16080 25660 0 0 $X=16000 $Y=25530
X54 12 M2_M1_CDNS_1 $T=18310 -40720 0 0 $X=18230 $Y=-40850
X55 12 M2_M1_CDNS_1 $T=18320 -47670 0 0 $X=18240 $Y=-47800
X56 11 M2_M1_CDNS_1 $T=18790 -38840 0 0 $X=18710 $Y=-38970
X57 11 M2_M1_CDNS_1 $T=18790 -37810 0 0 $X=18710 $Y=-37940
X58 25 M2_M1_CDNS_1 $T=19090 -43130 0 0 $X=19010 $Y=-43260
X59 25 M2_M1_CDNS_1 $T=19090 -36300 0 0 $X=19010 $Y=-36430
X60 11 M2_M1_CDNS_1 $T=19820 -21690 0 0 $X=19740 $Y=-21820
X61 11 M2_M1_CDNS_1 $T=19820 -19820 0 0 $X=19740 $Y=-19950
X62 11 M2_M1_CDNS_1 $T=19820 2640 0 0 $X=19740 $Y=2510
X63 11 M2_M1_CDNS_1 $T=19820 4510 0 0 $X=19740 $Y=4380
X64 13 M2_M1_CDNS_1 $T=19900 -550 0 0 $X=19820 $Y=-680
X65 13 M2_M1_CDNS_1 $T=19900 760 0 0 $X=19820 $Y=630
X66 24 M2_M1_CDNS_1 $T=19920 14200 0 0 $X=19840 $Y=14070
X67 24 M2_M1_CDNS_1 $T=19920 22950 0 0 $X=19840 $Y=22820
X68 14 M2_M1_CDNS_1 $T=20050 -24460 0 0 $X=19970 $Y=-24590
X69 14 M2_M1_CDNS_1 $T=20050 -23570 0 0 $X=19970 $Y=-23700
X70 2 M2_M1_CDNS_1 $T=20440 -7460 0 0 $X=20360 $Y=-7590
X71 2 M2_M1_CDNS_1 $T=20440 -3990 0 0 $X=20360 $Y=-4120
X72 2 M2_M1_CDNS_1 $T=20440 16870 0 0 $X=20360 $Y=16740
X73 2 M2_M1_CDNS_1 $T=20440 20340 0 0 $X=20360 $Y=20210
X74 26 M2_M1_CDNS_1 $T=20540 -33720 0 0 $X=20460 $Y=-33850
X75 27 M2_M1_CDNS_1 $T=20540 -9750 0 0 $X=20460 $Y=-9880
X76 28 M2_M1_CDNS_1 $T=20540 14580 0 0 $X=20460 $Y=14450
X77 7 M2_M1_CDNS_1 $T=20740 -6720 0 0 $X=20660 $Y=-6850
X78 7 M2_M1_CDNS_1 $T=20740 -4790 0 0 $X=20660 $Y=-4920
X79 6 M2_M1_CDNS_1 $T=20740 17610 0 0 $X=20660 $Y=17480
X80 6 M2_M1_CDNS_1 $T=20740 19540 0 0 $X=20660 $Y=19410
X81 29 M2_M1_CDNS_1 $T=20880 -34100 0 0 $X=20800 $Y=-34230
X82 30 M2_M1_CDNS_1 $T=20880 -10130 0 0 $X=20800 $Y=-10260
X83 31 M2_M1_CDNS_1 $T=20880 14200 0 0 $X=20800 $Y=14070
X84 2 M2_M1_CDNS_1 $T=21030 -31820 0 0 $X=20950 $Y=-31950
X85 2 M2_M1_CDNS_1 $T=21030 -28360 0 0 $X=20950 $Y=-28490
X86 8 M2_M1_CDNS_1 $T=21330 -31080 0 0 $X=21250 $Y=-31210
X87 8 M2_M1_CDNS_1 $T=21330 -29160 0 0 $X=21250 $Y=-29290
X88 10 M2_M1_CDNS_1 $T=23140 -34730 0 0 $X=23060 $Y=-34860
X89 10 M2_M1_CDNS_1 $T=23140 -33120 0 0 $X=23060 $Y=-33250
X90 29 M2_M1_CDNS_1 $T=23820 -34090 0 0 $X=23740 $Y=-34220
X91 29 M2_M1_CDNS_1 $T=23820 -27190 0 0 $X=23740 $Y=-27320
X92 26 M2_M1_CDNS_1 $T=24120 -33720 0 0 $X=24040 $Y=-33850
X93 26 M2_M1_CDNS_1 $T=24120 -31450 0 0 $X=24040 $Y=-31580
X94 30 M2_M1_CDNS_1 $T=24590 -10120 0 0 $X=24510 $Y=-10250
X95 30 M2_M1_CDNS_1 $T=24590 -2810 0 0 $X=24510 $Y=-2940
X96 27 M2_M1_CDNS_1 $T=24890 -9750 0 0 $X=24810 $Y=-9880
X97 27 M2_M1_CDNS_1 $T=24890 -7490 0 0 $X=24810 $Y=-7620
X98 28 M2_M1_CDNS_1 $T=24890 14580 0 0 $X=24810 $Y=14450
X99 28 M2_M1_CDNS_1 $T=24890 16840 0 0 $X=24810 $Y=16710
X100 11 M2_M1_CDNS_1 $T=25200 -29790 0 0 $X=25120 $Y=-29920
X101 11 M2_M1_CDNS_1 $T=25200 -19800 0 0 $X=25120 $Y=-19930
X102 11 M2_M1_CDNS_1 $T=25370 -5450 0 0 $X=25290 $Y=-5580
X103 11 M2_M1_CDNS_1 $T=25370 4530 0 0 $X=25290 $Y=4400
X104 3 M2_M1_CDNS_1 $T=25620 22990 0 0 $X=25540 $Y=22860
X105 3 M2_M1_CDNS_1 $T=25620 26860 0 0 $X=25540 $Y=26730
X106 5 M2_M1_CDNS_1 $T=25920 23730 0 0 $X=25840 $Y=23600
X107 5 M2_M1_CDNS_1 $T=25920 25660 0 0 $X=25840 $Y=25530
X108 10 M2_M1_CDNS_1 $T=27000 -33100 0 0 $X=26920 $Y=-33230
X109 10 M2_M1_CDNS_1 $T=27000 -23130 0 0 $X=26920 $Y=-23260
X110 10 M2_M1_CDNS_1 $T=27380 -10680 0 0 $X=27300 $Y=-10810
X111 10 M2_M1_CDNS_1 $T=27380 -8730 0 0 $X=27300 $Y=-8860
X112 10 M2_M1_CDNS_1 $T=29270 13650 0 0 $X=29190 $Y=13520
X113 10 M2_M1_CDNS_1 $T=29270 15600 0 0 $X=29190 $Y=15470
X114 10 M2_M1_CDNS_1 $T=29270 21670 0 0 $X=29190 $Y=21540
X115 31 M2_M1_CDNS_1 $T=29760 14210 0 0 $X=29680 $Y=14080
X116 31 M2_M1_CDNS_1 $T=29760 22950 0 0 $X=29680 $Y=22820
X117 32 M2_M1_CDNS_1 $T=33610 -45430 0 0 $X=33530 $Y=-45560
X118 32 M2_M1_CDNS_1 $T=33610 -43130 0 0 $X=33530 $Y=-43260
X119 33 M2_M1_CDNS_1 $T=33610 -21460 0 0 $X=33530 $Y=-21590
X120 33 M2_M1_CDNS_1 $T=33610 -19160 0 0 $X=33530 $Y=-19290
X121 34 M2_M1_CDNS_1 $T=33610 2870 0 0 $X=33530 $Y=2740
X122 34 M2_M1_CDNS_1 $T=33610 5170 0 0 $X=33530 $Y=5040
X123 20 M2_M1_CDNS_1 $T=33910 -26830 0 0 $X=33830 $Y=-26960
X124 20 M2_M1_CDNS_1 $T=33910 -15670 0 0 $X=33830 $Y=-15800
X125 23 M2_M1_CDNS_1 $T=33940 -2500 0 0 $X=33860 $Y=-2630
X126 23 M2_M1_CDNS_1 $T=33940 8660 0 0 $X=33860 $Y=8530
X127 11 M2_M1_CDNS_1 $T=34270 -37780 0 0 $X=34190 $Y=-37910
X128 11 M2_M1_CDNS_1 $T=34270 -29790 0 0 $X=34190 $Y=-29920
X129 11 M2_M1_CDNS_1 $T=34270 -13810 0 0 $X=34190 $Y=-13940
X130 11 M2_M1_CDNS_1 $T=34270 -5490 0 0 $X=34190 $Y=-5620
X131 11 M2_M1_CDNS_1 $T=34270 4550 0 0 $X=34190 $Y=4420
X132 11 M2_M1_CDNS_1 $T=34270 10520 0 0 $X=34190 $Y=10390
X133 11 M2_M1_CDNS_1 $T=34280 18840 0 0 $X=34200 $Y=18710
X134 11 M2_M1_CDNS_1 $T=34280 24950 0 0 $X=34200 $Y=24820
X135 15 M2_M1_CDNS_1 $T=34550 -47980 0 0 $X=34470 $Y=-48110
X136 15 M2_M1_CDNS_1 $T=34550 -39640 0 0 $X=34470 $Y=-39770
X137 3 M2_M1_CDNS_1 $T=35370 -7460 0 0 $X=35290 $Y=-7590
X138 3 M2_M1_CDNS_1 $T=35370 -3590 0 0 $X=35290 $Y=-3720
X139 3 M2_M1_CDNS_1 $T=35370 16870 0 0 $X=35290 $Y=16740
X140 3 M2_M1_CDNS_1 $T=35370 20740 0 0 $X=35290 $Y=20610
X141 35 M2_M1_CDNS_1 $T=35450 -33720 0 0 $X=35370 $Y=-33850
X142 36 M2_M1_CDNS_1 $T=35450 -9750 0 0 $X=35370 $Y=-9880
X143 37 M2_M1_CDNS_1 $T=35450 14580 0 0 $X=35370 $Y=14450
X144 7 M2_M1_CDNS_1 $T=35670 -6720 0 0 $X=35590 $Y=-6850
X145 7 M2_M1_CDNS_1 $T=35670 -4790 0 0 $X=35590 $Y=-4920
X146 6 M2_M1_CDNS_1 $T=35670 17610 0 0 $X=35590 $Y=17480
X147 6 M2_M1_CDNS_1 $T=35670 19540 0 0 $X=35590 $Y=19410
X148 38 M2_M1_CDNS_1 $T=35790 -34100 0 0 $X=35710 $Y=-34230
X149 39 M2_M1_CDNS_1 $T=35790 -10130 0 0 $X=35710 $Y=-10260
X150 40 M2_M1_CDNS_1 $T=35790 14200 0 0 $X=35710 $Y=14070
X151 3 M2_M1_CDNS_1 $T=35930 -31820 0 0 $X=35850 $Y=-31950
X152 3 M2_M1_CDNS_1 $T=35930 -27960 0 0 $X=35850 $Y=-28090
X153 8 M2_M1_CDNS_1 $T=36230 -31080 0 0 $X=36150 $Y=-31210
X154 8 M2_M1_CDNS_1 $T=36230 -29160 0 0 $X=36150 $Y=-29290
X155 10 M2_M1_CDNS_1 $T=37990 -34730 0 0 $X=37910 $Y=-34860
X156 10 M2_M1_CDNS_1 $T=37990 -33120 0 0 $X=37910 $Y=-33250
X157 38 M2_M1_CDNS_1 $T=38780 -34090 0 0 $X=38700 $Y=-34220
X158 38 M2_M1_CDNS_1 $T=38780 -24070 0 0 $X=38700 $Y=-24200
X159 35 M2_M1_CDNS_1 $T=39090 -33720 0 0 $X=39010 $Y=-33850
X160 35 M2_M1_CDNS_1 $T=39090 -31450 0 0 $X=39010 $Y=-31580
X161 39 M2_M1_CDNS_1 $T=39500 -10120 0 0 $X=39420 $Y=-10250
X162 39 M2_M1_CDNS_1 $T=39500 -3840 0 0 $X=39420 $Y=-3970
X163 36 M2_M1_CDNS_1 $T=39800 -9750 0 0 $X=39720 $Y=-9880
X164 36 M2_M1_CDNS_1 $T=39800 -7490 0 0 $X=39720 $Y=-7620
X165 37 M2_M1_CDNS_1 $T=39800 14580 0 0 $X=39720 $Y=14450
X166 37 M2_M1_CDNS_1 $T=39800 16840 0 0 $X=39720 $Y=16710
X167 10 M2_M1_CDNS_1 $T=41100 -8860 0 0 $X=41020 $Y=-8990
X168 10 M2_M1_CDNS_1 $T=41100 1210 0 0 $X=41020 $Y=1080
X169 4 M2_M1_CDNS_1 $T=42080 22950 0 0 $X=42000 $Y=22820
X170 4 M2_M1_CDNS_1 $T=42080 27260 0 0 $X=42000 $Y=27130
X171 5 M2_M1_CDNS_1 $T=42380 23690 0 0 $X=42300 $Y=23560
X172 5 M2_M1_CDNS_1 $T=42380 25660 0 0 $X=42300 $Y=25530
X173 4 M2_M1_CDNS_1 $T=42670 -31800 0 0 $X=42590 $Y=-31930
X174 4 M2_M1_CDNS_1 $T=42670 -27560 0 0 $X=42590 $Y=-27690
X175 8 M2_M1_CDNS_1 $T=42970 -31080 0 0 $X=42890 $Y=-31210
X176 8 M2_M1_CDNS_1 $T=42970 -29160 0 0 $X=42890 $Y=-29290
X177 40 M2_M1_CDNS_1 $T=44670 14210 0 0 $X=44590 $Y=14080
X178 40 M2_M1_CDNS_1 $T=44670 23320 0 0 $X=44590 $Y=23190
X179 4 M2_M1_CDNS_1 $T=45360 -7720 0 0 $X=45280 $Y=-7850
X180 4 M2_M1_CDNS_1 $T=45360 -3190 0 0 $X=45280 $Y=-3320
X181 4 M2_M1_CDNS_1 $T=45360 16610 0 0 $X=45280 $Y=16480
X182 4 M2_M1_CDNS_1 $T=45360 21140 0 0 $X=45280 $Y=21010
X183 7 M2_M1_CDNS_1 $T=45660 -6980 0 0 $X=45580 $Y=-7110
X184 7 M2_M1_CDNS_1 $T=45660 -4790 0 0 $X=45580 $Y=-4920
X185 6 M2_M1_CDNS_1 $T=45660 17350 0 0 $X=45580 $Y=17220
X186 6 M2_M1_CDNS_1 $T=45660 19540 0 0 $X=45580 $Y=19410
X187 41 M2_M1_CDNS_1 $T=48520 -45430 0 0 $X=48440 $Y=-45560
X188 41 M2_M1_CDNS_1 $T=48520 -43100 0 0 $X=48440 $Y=-43230
X189 42 M2_M1_CDNS_1 $T=48520 -21460 0 0 $X=48440 $Y=-21590
X190 42 M2_M1_CDNS_1 $T=48520 -19130 0 0 $X=48440 $Y=-19260
X191 43 M2_M1_CDNS_1 $T=48520 2870 0 0 $X=48440 $Y=2740
X192 43 M2_M1_CDNS_1 $T=48520 5200 0 0 $X=48440 $Y=5070
X193 29 M2_M1_CDNS_1 $T=48820 -27190 0 0 $X=48740 $Y=-27320
X194 29 M2_M1_CDNS_1 $T=48820 -15670 0 0 $X=48740 $Y=-15800
X195 30 M2_M1_CDNS_1 $T=48850 -2810 0 0 $X=48770 $Y=-2940
X196 30 M2_M1_CDNS_1 $T=48850 8660 0 0 $X=48770 $Y=8530
X197 16 M2_M1_CDNS_1 $T=48910 -48290 0 0 $X=48830 $Y=-48420
X198 16 M2_M1_CDNS_1 $T=48910 -39640 0 0 $X=48830 $Y=-39770
X199 44 M2_M1_CDNS_1 $T=49700 -31830 0 0 $X=49620 $Y=-31960
X200 45 M2_M1_CDNS_1 $T=49700 -9010 0 0 $X=49620 $Y=-9140
X201 11 M2_M1_CDNS_1 $T=49700 10520 0 0 $X=49620 $Y=10390
X202 46 M2_M1_CDNS_1 $T=50040 -23670 0 0 $X=49960 $Y=-23800
X203 47 M2_M1_CDNS_1 $T=50040 -7350 0 0 $X=49960 $Y=-7480
X204 48 M2_M1_CDNS_1 $T=50040 16980 0 0 $X=49960 $Y=16850
X205 11 M2_M1_CDNS_1 $T=52510 -28830 0 0 $X=52430 $Y=-28960
X206 49 M2_M1_CDNS_1 $T=52850 -34060 0 0 $X=52770 $Y=-34190
X207 11 M2_M1_CDNS_1 $T=54500 -28780 0 0 $X=54420 $Y=-28910
X208 11 M2_M1_CDNS_1 $T=54500 -19770 0 0 $X=54420 $Y=-19900
X209 10 M2_M1_CDNS_1 $T=56520 -24980 0 0 $X=56440 $Y=-25110
X210 10 M2_M1_CDNS_1 $T=56520 -23080 0 0 $X=56440 $Y=-23210
X211 49 M2_M1_CDNS_1 $T=62770 -45400 0 0 $X=62690 $Y=-45530
X212 49 M2_M1_CDNS_1 $T=62770 -34070 0 0 $X=62690 $Y=-34200
X213 46 M2_M1_CDNS_1 $T=62770 -23670 0 0 $X=62690 $Y=-23800
X214 46 M2_M1_CDNS_1 $T=62770 -21430 0 0 $X=62690 $Y=-21560
X215 45 M2_M1_CDNS_1 $T=62770 -9010 0 0 $X=62690 $Y=-9140
X216 45 M2_M1_CDNS_1 $T=62770 2900 0 0 $X=62690 $Y=2770
X217 17 M2_M1_CDNS_1 $T=63070 -48600 0 0 $X=62990 $Y=-48730
X218 17 M2_M1_CDNS_1 $T=63070 -39610 0 0 $X=62990 $Y=-39740
X219 38 M2_M1_CDNS_1 $T=63070 -24070 0 0 $X=62990 $Y=-24200
X220 38 M2_M1_CDNS_1 $T=63070 -15640 0 0 $X=62990 $Y=-15770
X221 39 M2_M1_CDNS_1 $T=63100 -3840 0 0 $X=63020 $Y=-3970
X222 39 M2_M1_CDNS_1 $T=63100 8690 0 0 $X=63020 $Y=8560
X223 18 M2_M1_CDNS_1 $T=63370 -49010 0 0 $X=63290 $Y=-49140
X224 18 M2_M1_CDNS_1 $T=63370 -30620 0 0 $X=63290 $Y=-30750
X225 11 10 19 1 8 143 NAND $T=14090 -32130 0 0 $X=11770 $Y=-33370
X226 11 10 26 2 8 168 NAND $T=23370 -32130 0 0 $X=21050 $Y=-33370
X227 11 10 35 3 8 193 NAND $T=38270 -32130 0 0 $X=35950 $Y=-33370
X228 11 10 40 4 5 195 NAND $T=44420 22640 0 0 $X=42100 $Y=21400
X229 11 10 47 4 7 197 NAND $T=47700 -8030 0 0 $X=45380 $Y=-9270
X230 11 10 48 4 6 196 NAND $T=47700 16300 0 0 $X=45380 $Y=15060
X231 26 29 11 10 25 15 32 85 81 84
+ 80 82 238 241 Full_Adder $T=29840 -46530 0 0 $X=19850 $Y=-47350
X232 27 30 11 10 50 20 33 78 74 77
+ 73 75 234 237 Full_Adder $T=29840 -22560 0 0 $X=19850 $Y=-23380
X233 28 31 11 10 51 23 34 71 67 70
+ 66 68 230 233 Full_Adder $T=29840 1770 0 0 $X=19850 $Y=950
X234 35 38 11 10 32 16 41 109 105 108
+ 104 106 250 253 Full_Adder $T=44750 -46530 0 0 $X=34760 $Y=-47350
X235 36 39 11 10 33 29 42 102 98 101
+ 97 99 246 249 Full_Adder $T=44750 -22560 0 0 $X=34760 $Y=-23380
X236 37 40 11 10 34 30 43 95 91 94
+ 90 92 242 245 Full_Adder $T=44750 1770 0 0 $X=34760 $Y=950
X237 44 46 11 10 41 17 49 133 129 132
+ 128 130 262 265 Full_Adder $T=59000 -46500 0 0 $X=49010 $Y=-47320
X238 45 47 11 10 42 38 46 126 122 125
+ 121 123 258 261 Full_Adder $T=59000 -22530 0 0 $X=49010 $Y=-23350
X239 11 48 11 10 43 39 45 119 115 118
+ 114 116 254 257 Full_Adder $T=59000 1800 0 0 $X=49010 $Y=980
X240 19 20 10 11 12 25 61 60 221 222
+ 223 135 136 Half_Adder $T=12680 -39880 0 0 $X=8840 $Y=-43630
X241 21 23 10 11 14 50 59 58 227 228
+ 229 141 142 Half_Adder $T=14110 -22730 0 0 $X=10270 $Y=-26480
X242 22 24 10 11 13 51 57 56 224 225
+ 226 139 140 Half_Adder $T=14110 1600 0 0 $X=10270 $Y=-2150
X243 11 49 10 11 18 52 112 111 266 267
+ 268 219 220 Half_Adder $T=55780 -29780 0 0 $X=51940 $Y=-33530
X244 11 10 1 5 9 55 134 AND $T=11720 21260 0 0 $X=8680 $Y=21410
X245 11 10 1 7 21 54 138 AND $T=13470 -9180 0 0 $X=10430 $Y=-9030
X246 11 10 1 6 22 53 137 AND $T=13470 15150 0 0 $X=10430 $Y=15300
X247 11 10 2 5 24 62 144 AND $T=18650 21260 0 0 $X=15610 $Y=21410
X248 11 10 2 7 27 64 146 AND $T=23310 -9180 0 0 $X=20270 $Y=-9030
X249 11 10 2 6 28 63 145 AND $T=23310 15150 0 0 $X=20270 $Y=15300
X250 11 10 3 5 31 86 169 AND $T=28490 21260 0 0 $X=25450 $Y=21410
X251 11 10 3 7 36 88 171 AND $T=38240 -9180 0 0 $X=35200 $Y=-9030
X252 11 10 3 6 37 87 170 AND $T=38240 15150 0 0 $X=35200 $Y=15300
X253 11 10 4 8 44 110 194 AND $T=45540 -33520 0 0 $X=42500 $Y=-33370
M0 55 5 11 11 g45p1svt w=2.4e-07 l=4.5e-08 ad=3.36e-14 as=3.36e-14 pd=7.6e-07 ps=7.6e-07 sa=1.4e-07 sb=1.4e-07 sca=16.0927 scb=0.0154531 scc=0.000419743 fw=2.4e-07 $X=9610 $Y=24030 $dt=1
M1 54 7 11 11 g45p1svt w=2.4e-07 l=4.5e-08 ad=3.36e-14 as=3.36e-14 pd=7.6e-07 ps=7.6e-07 sa=1.4e-07 sb=1.4e-07 sca=16.0927 scb=0.0154531 scc=0.000419743 fw=2.4e-07 $X=11360 $Y=-6410 $dt=1
M2 53 6 11 11 g45p1svt w=2.4e-07 l=4.5e-08 ad=3.36e-14 as=3.36e-14 pd=7.6e-07 ps=7.6e-07 sa=1.4e-07 sb=1.4e-07 sca=16.0927 scb=0.0154531 scc=0.000419743 fw=2.4e-07 $X=11360 $Y=17920 $dt=1
M3 9 55 11 11 g45p1svt w=2.4e-07 l=4.5e-08 ad=3.36e-14 as=3.36e-14 pd=7.6e-07 ps=7.6e-07 sa=1.4e-07 sb=1.4e-07 sca=15.9246 scb=0.0151668 scc=0.000414946 fw=2.4e-07 $X=12140 $Y=24030 $dt=1
M4 19 8 11 11 g45p1svt w=2.4e-07 l=4.5e-08 ad=3.36e-14 as=3.36e-14 pd=7.6e-07 ps=7.6e-07 sa=1.4e-07 sb=1.4e-07 sca=27.6029 scb=0.0286946 scc=0.00220115 fw=2.4e-07 $X=12510 $Y=-30750 $dt=1
M5 19 1 11 11 g45p1svt w=2.4e-07 l=4.5e-08 ad=3.36e-14 as=3.36e-14 pd=7.6e-07 ps=7.6e-07 sa=1.4e-07 sb=1.4e-07 sca=30.3216 scb=0.0333085 scc=0.0025237 fw=2.4e-07 $X=13760 $Y=-30750 $dt=1
M6 21 54 11 11 g45p1svt w=2.4e-07 l=4.5e-08 ad=3.36e-14 as=3.36e-14 pd=7.6e-07 ps=7.6e-07 sa=1.4e-07 sb=1.4e-07 sca=15.9246 scb=0.0151668 scc=0.000414946 fw=2.4e-07 $X=13890 $Y=-6410 $dt=1
M7 22 53 11 11 g45p1svt w=2.4e-07 l=4.5e-08 ad=3.36e-14 as=3.36e-14 pd=7.6e-07 ps=7.6e-07 sa=1.4e-07 sb=1.4e-07 sca=15.9246 scb=0.0151668 scc=0.000414946 fw=2.4e-07 $X=13890 $Y=17920 $dt=1
M8 62 5 11 11 g45p1svt w=2.4e-07 l=4.5e-08 ad=3.36e-14 as=3.36e-14 pd=7.6e-07 ps=7.6e-07 sa=1.4e-07 sb=1.4e-07 sca=16.0927 scb=0.0154531 scc=0.000419743 fw=2.4e-07 $X=16540 $Y=24030 $dt=1
M9 25 61 223 11 g45p1svt w=4.8e-07 l=4.5e-08 ad=6.72e-14 as=6.72e-14 pd=1.24e-06 ps=1.24e-06 sa=1.4e-07 sb=1.4e-07 sca=7.78706 scb=0.00554847 scc=0.000178111 fw=4.8e-07 $X=17070 $Y=-38400 $dt=1
M10 50 59 229 11 g45p1svt w=4.8e-07 l=4.5e-08 ad=6.72e-14 as=6.72e-14 pd=1.24e-06 ps=1.24e-06 sa=1.4e-07 sb=1.4e-07 sca=7.78706 scb=0.00554847 scc=0.000178111 fw=4.8e-07 $X=18500 $Y=-21250 $dt=1
M11 51 57 226 11 g45p1svt w=4.8e-07 l=4.5e-08 ad=6.72e-14 as=6.72e-14 pd=1.24e-06 ps=1.24e-06 sa=1.4e-07 sb=1.4e-07 sca=7.78706 scb=0.00554847 scc=0.000178111 fw=4.8e-07 $X=18500 $Y=3080 $dt=1
M12 24 62 11 11 g45p1svt w=2.4e-07 l=4.5e-08 ad=3.36e-14 as=3.36e-14 pd=7.6e-07 ps=7.6e-07 sa=1.4e-07 sb=1.4e-07 sca=15.9246 scb=0.0151668 scc=0.000414946 fw=2.4e-07 $X=19070 $Y=24030 $dt=1
M13 64 7 11 11 g45p1svt w=2.4e-07 l=4.5e-08 ad=3.36e-14 as=3.36e-14 pd=7.6e-07 ps=7.6e-07 sa=1.4e-07 sb=1.4e-07 sca=16.0927 scb=0.0154531 scc=0.000419743 fw=2.4e-07 $X=21200 $Y=-6410 $dt=1
M14 63 6 11 11 g45p1svt w=2.4e-07 l=4.5e-08 ad=3.36e-14 as=3.36e-14 pd=7.6e-07 ps=7.6e-07 sa=1.4e-07 sb=1.4e-07 sca=16.0927 scb=0.0154531 scc=0.000419743 fw=2.4e-07 $X=21200 $Y=17920 $dt=1
M15 85 26 11 11 g45p1svt w=2.4e-07 l=4.5e-08 ad=3.36e-14 as=3.36e-14 pd=7.6e-07 ps=7.6e-07 sa=1.4e-07 sb=1.4e-07 sca=22.1446 scb=0.0211749 scc=0.0017623 fw=2.4e-07 $X=21520 $Y=-44730 $dt=1
M16 78 27 11 11 g45p1svt w=2.4e-07 l=4.5e-08 ad=3.36e-14 as=3.36e-14 pd=7.6e-07 ps=7.6e-07 sa=1.4e-07 sb=1.4e-07 sca=20.4324 scb=0.0198648 scc=0.00175929 fw=2.4e-07 $X=21520 $Y=-20760 $dt=1
M17 71 28 11 11 g45p1svt w=2.4e-07 l=4.5e-08 ad=3.36e-14 as=3.36e-14 pd=7.6e-07 ps=7.6e-07 sa=1.4e-07 sb=1.4e-07 sca=20.4324 scb=0.0198648 scc=0.00175929 fw=2.4e-07 $X=21520 $Y=3570 $dt=1
M18 238 26 11 11 g45p1svt w=4.8e-07 l=4.5e-08 ad=6.72e-14 as=6.72e-14 pd=1.24e-06 ps=1.24e-06 sa=1.4e-07 sb=1.4e-07 sca=9.47395 scb=0.00759651 scc=0.000374483 fw=4.8e-07 $X=21650 $Y=-39250 $dt=1
M19 234 27 11 11 g45p1svt w=4.8e-07 l=4.5e-08 ad=6.72e-14 as=6.72e-14 pd=1.24e-06 ps=1.24e-06 sa=1.4e-07 sb=1.4e-07 sca=9.69279 scb=0.0076507 scc=0.000374491 fw=4.8e-07 $X=21650 $Y=-15280 $dt=1
M20 230 28 11 11 g45p1svt w=4.8e-07 l=4.5e-08 ad=6.72e-14 as=6.72e-14 pd=1.24e-06 ps=1.24e-06 sa=1.4e-07 sb=1.4e-07 sca=9.69279 scb=0.0076507 scc=0.000374491 fw=4.8e-07 $X=21650 $Y=9050 $dt=1
M21 80 29 11 11 g45p1svt w=2.4e-07 l=4.5e-08 ad=3.36e-14 as=3.36e-14 pd=7.6e-07 ps=7.6e-07 sa=1.4e-07 sb=1.4e-07 sca=34.1422 scb=0.0251568 scc=0.00441949 fw=2.4e-07 $X=21660 $Y=-37240 $dt=1
M22 73 30 11 11 g45p1svt w=2.4e-07 l=4.5e-08 ad=3.36e-14 as=3.36e-14 pd=7.6e-07 ps=7.6e-07 sa=1.4e-07 sb=1.4e-07 sca=34.3484 scb=0.025207 scc=0.0044195 fw=2.4e-07 $X=21660 $Y=-13270 $dt=1
M23 66 31 11 11 g45p1svt w=2.4e-07 l=4.5e-08 ad=3.36e-14 as=3.36e-14 pd=7.6e-07 ps=7.6e-07 sa=1.4e-07 sb=1.4e-07 sca=34.3484 scb=0.025207 scc=0.0044195 fw=2.4e-07 $X=21660 $Y=11060 $dt=1
M24 26 8 11 11 g45p1svt w=2.4e-07 l=4.5e-08 ad=3.36e-14 as=3.36e-14 pd=7.6e-07 ps=7.6e-07 sa=1.4e-07 sb=1.4e-07 sca=27.6029 scb=0.0286946 scc=0.00220115 fw=2.4e-07 $X=21790 $Y=-30750 $dt=1
M25 85 29 11 11 g45p1svt w=2.4e-07 l=4.5e-08 ad=3.36e-14 as=3.36e-14 pd=7.6e-07 ps=7.6e-07 sa=1.4e-07 sb=1.4e-07 sca=20.4324 scb=0.0198648 scc=0.00175929 fw=2.4e-07 $X=22770 $Y=-44730 $dt=1
M26 78 30 11 11 g45p1svt w=2.4e-07 l=4.5e-08 ad=3.36e-14 as=3.36e-14 pd=7.6e-07 ps=7.6e-07 sa=1.4e-07 sb=1.4e-07 sca=20.4324 scb=0.0198648 scc=0.00175929 fw=2.4e-07 $X=22770 $Y=-20760 $dt=1
M27 71 31 11 11 g45p1svt w=2.4e-07 l=4.5e-08 ad=3.36e-14 as=3.36e-14 pd=7.6e-07 ps=7.6e-07 sa=1.4e-07 sb=1.4e-07 sca=20.4324 scb=0.0198648 scc=0.00175929 fw=2.4e-07 $X=22770 $Y=3570 $dt=1
M28 26 2 11 11 g45p1svt w=2.4e-07 l=4.5e-08 ad=3.36e-14 as=3.36e-14 pd=7.6e-07 ps=7.6e-07 sa=1.4e-07 sb=1.4e-07 sca=30.3216 scb=0.0333085 scc=0.0025237 fw=2.4e-07 $X=23040 $Y=-30750 $dt=1
M29 27 64 11 11 g45p1svt w=2.4e-07 l=4.5e-08 ad=3.36e-14 as=3.36e-14 pd=7.6e-07 ps=7.6e-07 sa=1.4e-07 sb=1.4e-07 sca=15.9246 scb=0.0151668 scc=0.000414946 fw=2.4e-07 $X=23730 $Y=-6410 $dt=1
M30 28 63 11 11 g45p1svt w=2.4e-07 l=4.5e-08 ad=3.36e-14 as=3.36e-14 pd=7.6e-07 ps=7.6e-07 sa=1.4e-07 sb=1.4e-07 sca=15.9246 scb=0.0151668 scc=0.000414946 fw=2.4e-07 $X=23730 $Y=17920 $dt=1
M31 86 5 11 11 g45p1svt w=2.4e-07 l=4.5e-08 ad=3.36e-14 as=3.36e-14 pd=7.6e-07 ps=7.6e-07 sa=1.4e-07 sb=1.4e-07 sca=16.0927 scb=0.0154531 scc=0.000419743 fw=2.4e-07 $X=26380 $Y=24030 $dt=1
M32 84 81 11 11 g45p1svt w=2.4e-07 l=4.5e-08 ad=3.36e-14 as=3.36e-14 pd=7.6e-07 ps=7.6e-07 sa=1.4e-07 sb=1.4e-07 sca=20.4324 scb=0.0198648 scc=0.00175929 fw=2.4e-07 $X=28140 $Y=-44730 $dt=1
M33 77 74 11 11 g45p1svt w=2.4e-07 l=4.5e-08 ad=3.36e-14 as=3.36e-14 pd=7.6e-07 ps=7.6e-07 sa=1.4e-07 sb=1.4e-07 sca=20.4324 scb=0.0198648 scc=0.00175929 fw=2.4e-07 $X=28140 $Y=-20760 $dt=1
M34 70 67 11 11 g45p1svt w=2.4e-07 l=4.5e-08 ad=3.36e-14 as=3.36e-14 pd=7.6e-07 ps=7.6e-07 sa=1.4e-07 sb=1.4e-07 sca=20.4324 scb=0.0198648 scc=0.00175929 fw=2.4e-07 $X=28140 $Y=3570 $dt=1
M35 31 86 11 11 g45p1svt w=2.4e-07 l=4.5e-08 ad=3.36e-14 as=3.36e-14 pd=7.6e-07 ps=7.6e-07 sa=1.4e-07 sb=1.4e-07 sca=15.9246 scb=0.0151668 scc=0.000414946 fw=2.4e-07 $X=28910 $Y=24030 $dt=1
M36 84 25 11 11 g45p1svt w=2.4e-07 l=4.5e-08 ad=3.36e-14 as=3.36e-14 pd=7.6e-07 ps=7.6e-07 sa=1.4e-07 sb=1.4e-07 sca=20.4324 scb=0.0198648 scc=0.00175929 fw=2.4e-07 $X=29390 $Y=-44730 $dt=1
M37 77 50 11 11 g45p1svt w=2.4e-07 l=4.5e-08 ad=3.36e-14 as=3.36e-14 pd=7.6e-07 ps=7.6e-07 sa=1.4e-07 sb=1.4e-07 sca=20.4324 scb=0.0198648 scc=0.00175929 fw=2.4e-07 $X=29390 $Y=-20760 $dt=1
M38 70 51 11 11 g45p1svt w=2.4e-07 l=4.5e-08 ad=3.36e-14 as=3.36e-14 pd=7.6e-07 ps=7.6e-07 sa=1.4e-07 sb=1.4e-07 sca=20.4324 scb=0.0198648 scc=0.00175929 fw=2.4e-07 $X=29390 $Y=3570 $dt=1
M39 32 84 11 11 g45p1svt w=2.4e-07 l=4.5e-08 ad=3.36e-14 as=3.36e-14 pd=7.6e-07 ps=7.6e-07 sa=1.4e-07 sb=1.4e-07 sca=20.4324 scb=0.0198648 scc=0.00175929 fw=2.4e-07 $X=31350 $Y=-44730 $dt=1
M40 33 77 11 11 g45p1svt w=2.4e-07 l=4.5e-08 ad=3.36e-14 as=3.36e-14 pd=7.6e-07 ps=7.6e-07 sa=1.4e-07 sb=1.4e-07 sca=20.4324 scb=0.0198648 scc=0.00175929 fw=2.4e-07 $X=31350 $Y=-20760 $dt=1
M41 34 70 11 11 g45p1svt w=2.4e-07 l=4.5e-08 ad=3.36e-14 as=3.36e-14 pd=7.6e-07 ps=7.6e-07 sa=1.4e-07 sb=1.4e-07 sca=20.4324 scb=0.0198648 scc=0.00175929 fw=2.4e-07 $X=31350 $Y=3570 $dt=1
M42 82 25 11 11 g45p1svt w=2.4e-07 l=4.5e-08 ad=3.36e-14 as=3.36e-14 pd=7.6e-07 ps=7.6e-07 sa=1.4e-07 sb=1.4e-07 sca=34.1422 scb=0.0251568 scc=0.00441949 fw=2.4e-07 $X=32130 $Y=-37240 $dt=1
M43 75 50 11 11 g45p1svt w=2.4e-07 l=4.5e-08 ad=3.36e-14 as=3.36e-14 pd=7.6e-07 ps=7.6e-07 sa=1.4e-07 sb=1.4e-07 sca=34.1422 scb=0.0251568 scc=0.00441949 fw=2.4e-07 $X=32130 $Y=-13270 $dt=1
M44 68 51 11 11 g45p1svt w=2.4e-07 l=4.5e-08 ad=3.36e-14 as=3.36e-14 pd=7.6e-07 ps=7.6e-07 sa=1.4e-07 sb=1.4e-07 sca=34.1422 scb=0.0251568 scc=0.00441949 fw=2.4e-07 $X=32130 $Y=11060 $dt=1
M45 32 85 11 11 g45p1svt w=2.4e-07 l=4.5e-08 ad=3.36e-14 as=3.36e-14 pd=7.6e-07 ps=7.6e-07 sa=1.4e-07 sb=1.4e-07 sca=20.4324 scb=0.0198648 scc=0.00175929 fw=2.4e-07 $X=32600 $Y=-44730 $dt=1
M46 33 78 11 11 g45p1svt w=2.4e-07 l=4.5e-08 ad=3.36e-14 as=3.36e-14 pd=7.6e-07 ps=7.6e-07 sa=1.4e-07 sb=1.4e-07 sca=20.4324 scb=0.0198648 scc=0.00175929 fw=2.4e-07 $X=32600 $Y=-20760 $dt=1
M47 34 71 11 11 g45p1svt w=2.4e-07 l=4.5e-08 ad=3.36e-14 as=3.36e-14 pd=7.6e-07 ps=7.6e-07 sa=1.4e-07 sb=1.4e-07 sca=20.4324 scb=0.0198648 scc=0.00175929 fw=2.4e-07 $X=32600 $Y=3570 $dt=1
M48 15 81 241 11 g45p1svt w=4.8e-07 l=4.5e-08 ad=6.72e-14 as=6.72e-14 pd=1.24e-06 ps=1.24e-06 sa=1.4e-07 sb=1.4e-07 sca=9.47395 scb=0.00759651 scc=0.000374483 fw=4.8e-07 $X=32630 $Y=-39250 $dt=1
M49 20 74 237 11 g45p1svt w=4.8e-07 l=4.5e-08 ad=6.72e-14 as=6.72e-14 pd=1.24e-06 ps=1.24e-06 sa=1.4e-07 sb=1.4e-07 sca=9.47395 scb=0.00759651 scc=0.000374483 fw=4.8e-07 $X=32630 $Y=-15280 $dt=1
M50 23 67 233 11 g45p1svt w=4.8e-07 l=4.5e-08 ad=6.72e-14 as=6.72e-14 pd=1.24e-06 ps=1.24e-06 sa=1.4e-07 sb=1.4e-07 sca=9.47395 scb=0.00759651 scc=0.000374483 fw=4.8e-07 $X=32630 $Y=9050 $dt=1
M51 88 7 11 11 g45p1svt w=2.4e-07 l=4.5e-08 ad=3.36e-14 as=3.36e-14 pd=7.6e-07 ps=7.6e-07 sa=1.4e-07 sb=1.4e-07 sca=16.0927 scb=0.0154531 scc=0.000419743 fw=2.4e-07 $X=36130 $Y=-6410 $dt=1
M52 87 6 11 11 g45p1svt w=2.4e-07 l=4.5e-08 ad=3.36e-14 as=3.36e-14 pd=7.6e-07 ps=7.6e-07 sa=1.4e-07 sb=1.4e-07 sca=16.0927 scb=0.0154531 scc=0.000419743 fw=2.4e-07 $X=36130 $Y=17920 $dt=1
M53 109 35 11 11 g45p1svt w=2.4e-07 l=4.5e-08 ad=3.36e-14 as=3.36e-14 pd=7.6e-07 ps=7.6e-07 sa=1.4e-07 sb=1.4e-07 sca=20.4324 scb=0.0198648 scc=0.00175929 fw=2.4e-07 $X=36430 $Y=-44730 $dt=1
M54 102 36 11 11 g45p1svt w=2.4e-07 l=4.5e-08 ad=3.36e-14 as=3.36e-14 pd=7.6e-07 ps=7.6e-07 sa=1.4e-07 sb=1.4e-07 sca=20.4324 scb=0.0198648 scc=0.00175929 fw=2.4e-07 $X=36430 $Y=-20760 $dt=1
M55 95 37 11 11 g45p1svt w=2.4e-07 l=4.5e-08 ad=3.36e-14 as=3.36e-14 pd=7.6e-07 ps=7.6e-07 sa=1.4e-07 sb=1.4e-07 sca=20.4324 scb=0.0198648 scc=0.00175929 fw=2.4e-07 $X=36430 $Y=3570 $dt=1
M56 250 35 11 11 g45p1svt w=4.8e-07 l=4.5e-08 ad=6.72e-14 as=6.72e-14 pd=1.24e-06 ps=1.24e-06 sa=1.4e-07 sb=1.4e-07 sca=9.47395 scb=0.00759651 scc=0.000374483 fw=4.8e-07 $X=36560 $Y=-39250 $dt=1
M57 246 36 11 11 g45p1svt w=4.8e-07 l=4.5e-08 ad=6.72e-14 as=6.72e-14 pd=1.24e-06 ps=1.24e-06 sa=1.4e-07 sb=1.4e-07 sca=9.47395 scb=0.00759651 scc=0.000374483 fw=4.8e-07 $X=36560 $Y=-15280 $dt=1
M58 242 37 11 11 g45p1svt w=4.8e-07 l=4.5e-08 ad=6.72e-14 as=6.72e-14 pd=1.24e-06 ps=1.24e-06 sa=1.4e-07 sb=1.4e-07 sca=9.47395 scb=0.00759651 scc=0.000374483 fw=4.8e-07 $X=36560 $Y=9050 $dt=1
M59 104 38 11 11 g45p1svt w=2.4e-07 l=4.5e-08 ad=3.36e-14 as=3.36e-14 pd=7.6e-07 ps=7.6e-07 sa=1.4e-07 sb=1.4e-07 sca=34.1422 scb=0.0251568 scc=0.00441949 fw=2.4e-07 $X=36570 $Y=-37240 $dt=1
M60 97 39 11 11 g45p1svt w=2.4e-07 l=4.5e-08 ad=3.36e-14 as=3.36e-14 pd=7.6e-07 ps=7.6e-07 sa=1.4e-07 sb=1.4e-07 sca=34.1422 scb=0.0251568 scc=0.00441949 fw=2.4e-07 $X=36570 $Y=-13270 $dt=1
M61 90 40 11 11 g45p1svt w=2.4e-07 l=4.5e-08 ad=3.36e-14 as=3.36e-14 pd=7.6e-07 ps=7.6e-07 sa=1.4e-07 sb=1.4e-07 sca=34.1422 scb=0.0251568 scc=0.00441949 fw=2.4e-07 $X=36570 $Y=11060 $dt=1
M62 35 8 11 11 g45p1svt w=2.4e-07 l=4.5e-08 ad=3.36e-14 as=3.36e-14 pd=7.6e-07 ps=7.6e-07 sa=1.4e-07 sb=1.4e-07 sca=27.6029 scb=0.0286946 scc=0.00220115 fw=2.4e-07 $X=36690 $Y=-30750 $dt=1
M63 109 38 11 11 g45p1svt w=2.4e-07 l=4.5e-08 ad=3.36e-14 as=3.36e-14 pd=7.6e-07 ps=7.6e-07 sa=1.4e-07 sb=1.4e-07 sca=20.4324 scb=0.0198648 scc=0.00175929 fw=2.4e-07 $X=37680 $Y=-44730 $dt=1
M64 102 39 11 11 g45p1svt w=2.4e-07 l=4.5e-08 ad=3.36e-14 as=3.36e-14 pd=7.6e-07 ps=7.6e-07 sa=1.4e-07 sb=1.4e-07 sca=20.4324 scb=0.0198648 scc=0.00175929 fw=2.4e-07 $X=37680 $Y=-20760 $dt=1
M65 95 40 11 11 g45p1svt w=2.4e-07 l=4.5e-08 ad=3.36e-14 as=3.36e-14 pd=7.6e-07 ps=7.6e-07 sa=1.4e-07 sb=1.4e-07 sca=20.4324 scb=0.0198648 scc=0.00175929 fw=2.4e-07 $X=37680 $Y=3570 $dt=1
M66 35 3 11 11 g45p1svt w=2.4e-07 l=4.5e-08 ad=3.36e-14 as=3.36e-14 pd=7.6e-07 ps=7.6e-07 sa=1.4e-07 sb=1.4e-07 sca=30.3216 scb=0.0333085 scc=0.0025237 fw=2.4e-07 $X=37940 $Y=-30750 $dt=1
M67 36 88 11 11 g45p1svt w=2.4e-07 l=4.5e-08 ad=3.36e-14 as=3.36e-14 pd=7.6e-07 ps=7.6e-07 sa=1.4e-07 sb=1.4e-07 sca=15.9246 scb=0.0151668 scc=0.000414946 fw=2.4e-07 $X=38660 $Y=-6410 $dt=1
M68 37 87 11 11 g45p1svt w=2.4e-07 l=4.5e-08 ad=3.36e-14 as=3.36e-14 pd=7.6e-07 ps=7.6e-07 sa=1.4e-07 sb=1.4e-07 sca=15.9246 scb=0.0151668 scc=0.000414946 fw=2.4e-07 $X=38660 $Y=17920 $dt=1
M69 40 5 11 11 g45p1svt w=2.4e-07 l=4.5e-08 ad=3.36e-14 as=3.36e-14 pd=7.6e-07 ps=7.6e-07 sa=1.4e-07 sb=1.4e-07 sca=27.457 scb=0.0286619 scc=0.00220114 fw=2.4e-07 $X=42840 $Y=24020 $dt=1
M70 108 105 11 11 g45p1svt w=2.4e-07 l=4.5e-08 ad=3.36e-14 as=3.36e-14 pd=7.6e-07 ps=7.6e-07 sa=1.4e-07 sb=1.4e-07 sca=20.4324 scb=0.0198648 scc=0.00175929 fw=2.4e-07 $X=43050 $Y=-44730 $dt=1
M71 101 98 11 11 g45p1svt w=2.4e-07 l=4.5e-08 ad=3.36e-14 as=3.36e-14 pd=7.6e-07 ps=7.6e-07 sa=1.4e-07 sb=1.4e-07 sca=20.4324 scb=0.0198648 scc=0.00175929 fw=2.4e-07 $X=43050 $Y=-20760 $dt=1
M72 94 91 11 11 g45p1svt w=2.4e-07 l=4.5e-08 ad=3.36e-14 as=3.36e-14 pd=7.6e-07 ps=7.6e-07 sa=1.4e-07 sb=1.4e-07 sca=20.4324 scb=0.0198648 scc=0.00175929 fw=2.4e-07 $X=43050 $Y=3570 $dt=1
M73 110 8 11 11 g45p1svt w=2.4e-07 l=4.5e-08 ad=3.36e-14 as=3.36e-14 pd=7.6e-07 ps=7.6e-07 sa=1.4e-07 sb=1.4e-07 sca=16.0927 scb=0.0154531 scc=0.000419743 fw=2.4e-07 $X=43430 $Y=-30750 $dt=1
M74 40 4 11 11 g45p1svt w=2.4e-07 l=4.5e-08 ad=3.36e-14 as=3.36e-14 pd=7.6e-07 ps=7.6e-07 sa=1.4e-07 sb=1.4e-07 sca=21.9108 scb=0.0209201 scc=0.00204429 fw=2.4e-07 $X=44090 $Y=24020 $dt=1
M75 108 32 11 11 g45p1svt w=2.4e-07 l=4.5e-08 ad=3.36e-14 as=3.36e-14 pd=7.6e-07 ps=7.6e-07 sa=1.4e-07 sb=1.4e-07 sca=20.4324 scb=0.0198648 scc=0.00175929 fw=2.4e-07 $X=44300 $Y=-44730 $dt=1
M76 101 33 11 11 g45p1svt w=2.4e-07 l=4.5e-08 ad=3.36e-14 as=3.36e-14 pd=7.6e-07 ps=7.6e-07 sa=1.4e-07 sb=1.4e-07 sca=20.4324 scb=0.0198648 scc=0.00175929 fw=2.4e-07 $X=44300 $Y=-20760 $dt=1
M77 94 34 11 11 g45p1svt w=2.4e-07 l=4.5e-08 ad=3.36e-14 as=3.36e-14 pd=7.6e-07 ps=7.6e-07 sa=1.4e-07 sb=1.4e-07 sca=20.4324 scb=0.0198648 scc=0.00175929 fw=2.4e-07 $X=44300 $Y=3570 $dt=1
M78 44 110 11 11 g45p1svt w=2.4e-07 l=4.5e-08 ad=3.36e-14 as=3.36e-14 pd=7.6e-07 ps=7.6e-07 sa=1.4e-07 sb=1.4e-07 sca=15.9246 scb=0.0151668 scc=0.000414946 fw=2.4e-07 $X=45960 $Y=-30750 $dt=1
M79 47 7 11 11 g45p1svt w=2.4e-07 l=4.5e-08 ad=3.36e-14 as=3.36e-14 pd=7.6e-07 ps=7.6e-07 sa=1.4e-07 sb=1.4e-07 sca=27.6029 scb=0.0286946 scc=0.00220115 fw=2.4e-07 $X=46120 $Y=-6650 $dt=1
M80 48 6 11 11 g45p1svt w=2.4e-07 l=4.5e-08 ad=3.36e-14 as=3.36e-14 pd=7.6e-07 ps=7.6e-07 sa=1.4e-07 sb=1.4e-07 sca=27.6029 scb=0.0286946 scc=0.00220115 fw=2.4e-07 $X=46120 $Y=17680 $dt=1
M81 41 108 11 11 g45p1svt w=2.4e-07 l=4.5e-08 ad=3.36e-14 as=3.36e-14 pd=7.6e-07 ps=7.6e-07 sa=1.4e-07 sb=1.4e-07 sca=20.4324 scb=0.0198648 scc=0.00175929 fw=2.4e-07 $X=46260 $Y=-44730 $dt=1
M82 42 101 11 11 g45p1svt w=2.4e-07 l=4.5e-08 ad=3.36e-14 as=3.36e-14 pd=7.6e-07 ps=7.6e-07 sa=1.4e-07 sb=1.4e-07 sca=20.4324 scb=0.0198648 scc=0.00175929 fw=2.4e-07 $X=46260 $Y=-20760 $dt=1
M83 43 94 11 11 g45p1svt w=2.4e-07 l=4.5e-08 ad=3.36e-14 as=3.36e-14 pd=7.6e-07 ps=7.6e-07 sa=1.4e-07 sb=1.4e-07 sca=20.4324 scb=0.0198648 scc=0.00175929 fw=2.4e-07 $X=46260 $Y=3570 $dt=1
M84 106 32 11 11 g45p1svt w=2.4e-07 l=4.5e-08 ad=3.36e-14 as=3.36e-14 pd=7.6e-07 ps=7.6e-07 sa=1.4e-07 sb=1.4e-07 sca=34.1422 scb=0.0251568 scc=0.00441949 fw=2.4e-07 $X=47040 $Y=-37240 $dt=1
M85 99 33 11 11 g45p1svt w=2.4e-07 l=4.5e-08 ad=3.36e-14 as=3.36e-14 pd=7.6e-07 ps=7.6e-07 sa=1.4e-07 sb=1.4e-07 sca=34.1422 scb=0.0251568 scc=0.00441949 fw=2.4e-07 $X=47040 $Y=-13270 $dt=1
M86 92 34 11 11 g45p1svt w=2.4e-07 l=4.5e-08 ad=3.36e-14 as=3.36e-14 pd=7.6e-07 ps=7.6e-07 sa=1.4e-07 sb=1.4e-07 sca=34.1422 scb=0.0251568 scc=0.00441949 fw=2.4e-07 $X=47040 $Y=11060 $dt=1
M87 47 4 11 11 g45p1svt w=2.4e-07 l=4.5e-08 ad=3.36e-14 as=3.36e-14 pd=7.6e-07 ps=7.6e-07 sa=1.4e-07 sb=1.4e-07 sca=30.3216 scb=0.0333085 scc=0.0025237 fw=2.4e-07 $X=47370 $Y=-6650 $dt=1
M88 48 4 11 11 g45p1svt w=2.4e-07 l=4.5e-08 ad=3.36e-14 as=3.36e-14 pd=7.6e-07 ps=7.6e-07 sa=1.4e-07 sb=1.4e-07 sca=30.3216 scb=0.0333085 scc=0.0025237 fw=2.4e-07 $X=47370 $Y=17680 $dt=1
M89 41 109 11 11 g45p1svt w=2.4e-07 l=4.5e-08 ad=3.36e-14 as=3.36e-14 pd=7.6e-07 ps=7.6e-07 sa=1.4e-07 sb=1.4e-07 sca=20.4324 scb=0.0198648 scc=0.00175929 fw=2.4e-07 $X=47510 $Y=-44730 $dt=1
M90 42 102 11 11 g45p1svt w=2.4e-07 l=4.5e-08 ad=3.36e-14 as=3.36e-14 pd=7.6e-07 ps=7.6e-07 sa=1.4e-07 sb=1.4e-07 sca=20.4324 scb=0.0198648 scc=0.00175929 fw=2.4e-07 $X=47510 $Y=-20760 $dt=1
M91 43 95 11 11 g45p1svt w=2.4e-07 l=4.5e-08 ad=3.36e-14 as=3.36e-14 pd=7.6e-07 ps=7.6e-07 sa=1.4e-07 sb=1.4e-07 sca=20.4324 scb=0.0198648 scc=0.00175929 fw=2.4e-07 $X=47510 $Y=3570 $dt=1
M92 16 105 253 11 g45p1svt w=4.8e-07 l=4.5e-08 ad=6.72e-14 as=6.72e-14 pd=1.24e-06 ps=1.24e-06 sa=1.4e-07 sb=1.4e-07 sca=9.47395 scb=0.00759651 scc=0.000374483 fw=4.8e-07 $X=47540 $Y=-39250 $dt=1
M93 29 98 249 11 g45p1svt w=4.8e-07 l=4.5e-08 ad=6.72e-14 as=6.72e-14 pd=1.24e-06 ps=1.24e-06 sa=1.4e-07 sb=1.4e-07 sca=9.47395 scb=0.00759651 scc=0.000374483 fw=4.8e-07 $X=47540 $Y=-15280 $dt=1
M94 30 91 245 11 g45p1svt w=4.8e-07 l=4.5e-08 ad=6.72e-14 as=6.72e-14 pd=1.24e-06 ps=1.24e-06 sa=1.4e-07 sb=1.4e-07 sca=9.47395 scb=0.00759651 scc=0.000374483 fw=4.8e-07 $X=47540 $Y=9050 $dt=1
M95 133 44 11 11 g45p1svt w=2.4e-07 l=4.5e-08 ad=3.36e-14 as=3.36e-14 pd=7.6e-07 ps=7.6e-07 sa=1.4e-07 sb=1.4e-07 sca=20.4324 scb=0.0198648 scc=0.00175929 fw=2.4e-07 $X=50680 $Y=-44700 $dt=1
M96 126 45 11 11 g45p1svt w=2.4e-07 l=4.5e-08 ad=3.36e-14 as=3.36e-14 pd=7.6e-07 ps=7.6e-07 sa=1.4e-07 sb=1.4e-07 sca=20.4324 scb=0.0198648 scc=0.00175929 fw=2.4e-07 $X=50680 $Y=-20730 $dt=1
M97 119 11 11 11 g45p1svt w=2.4e-07 l=4.5e-08 ad=3.36e-14 as=3.36e-14 pd=7.6e-07 ps=7.6e-07 sa=1.4e-07 sb=1.4e-07 sca=20.4324 scb=0.0198648 scc=0.00175929 fw=2.4e-07 $X=50680 $Y=3600 $dt=1
M98 262 44 11 11 g45p1svt w=4.8e-07 l=4.5e-08 ad=6.72e-14 as=6.72e-14 pd=1.24e-06 ps=1.24e-06 sa=1.4e-07 sb=1.4e-07 sca=9.47395 scb=0.00759651 scc=0.000374483 fw=4.8e-07 $X=50810 $Y=-39220 $dt=1
M99 258 45 11 11 g45p1svt w=4.8e-07 l=4.5e-08 ad=6.72e-14 as=6.72e-14 pd=1.24e-06 ps=1.24e-06 sa=1.4e-07 sb=1.4e-07 sca=9.47395 scb=0.00759651 scc=0.000374483 fw=4.8e-07 $X=50810 $Y=-15250 $dt=1
M100 254 11 11 11 g45p1svt w=4.8e-07 l=4.5e-08 ad=6.72e-14 as=6.72e-14 pd=1.24e-06 ps=1.24e-06 sa=1.4e-07 sb=1.4e-07 sca=9.47395 scb=0.00759651 scc=0.000374483 fw=4.8e-07 $X=50810 $Y=9080 $dt=1
M101 128 46 11 11 g45p1svt w=2.4e-07 l=4.5e-08 ad=3.36e-14 as=3.36e-14 pd=7.6e-07 ps=7.6e-07 sa=1.4e-07 sb=1.4e-07 sca=34.1422 scb=0.0251568 scc=0.00441949 fw=2.4e-07 $X=50820 $Y=-37210 $dt=1
M102 121 47 11 11 g45p1svt w=2.4e-07 l=4.5e-08 ad=3.36e-14 as=3.36e-14 pd=7.6e-07 ps=7.6e-07 sa=1.4e-07 sb=1.4e-07 sca=34.1422 scb=0.0251568 scc=0.00441949 fw=2.4e-07 $X=50820 $Y=-13240 $dt=1
M103 114 48 11 11 g45p1svt w=2.4e-07 l=4.5e-08 ad=3.36e-14 as=3.36e-14 pd=7.6e-07 ps=7.6e-07 sa=1.4e-07 sb=1.4e-07 sca=34.1422 scb=0.0251568 scc=0.00441949 fw=2.4e-07 $X=50820 $Y=11090 $dt=1
M104 133 46 11 11 g45p1svt w=2.4e-07 l=4.5e-08 ad=3.36e-14 as=3.36e-14 pd=7.6e-07 ps=7.6e-07 sa=1.4e-07 sb=1.4e-07 sca=20.4324 scb=0.0198648 scc=0.00175929 fw=2.4e-07 $X=51930 $Y=-44700 $dt=1
M105 126 47 11 11 g45p1svt w=2.4e-07 l=4.5e-08 ad=3.36e-14 as=3.36e-14 pd=7.6e-07 ps=7.6e-07 sa=1.4e-07 sb=1.4e-07 sca=20.4324 scb=0.0198648 scc=0.00175929 fw=2.4e-07 $X=51930 $Y=-20730 $dt=1
M106 119 48 11 11 g45p1svt w=2.4e-07 l=4.5e-08 ad=3.36e-14 as=3.36e-14 pd=7.6e-07 ps=7.6e-07 sa=1.4e-07 sb=1.4e-07 sca=20.4324 scb=0.0198648 scc=0.00175929 fw=2.4e-07 $X=51930 $Y=3600 $dt=1
M107 132 129 11 11 g45p1svt w=2.4e-07 l=4.5e-08 ad=3.36e-14 as=3.36e-14 pd=7.6e-07 ps=7.6e-07 sa=1.4e-07 sb=1.4e-07 sca=20.4324 scb=0.0198648 scc=0.00175929 fw=2.4e-07 $X=57300 $Y=-44700 $dt=1
M108 125 122 11 11 g45p1svt w=2.4e-07 l=4.5e-08 ad=3.36e-14 as=3.36e-14 pd=7.6e-07 ps=7.6e-07 sa=1.4e-07 sb=1.4e-07 sca=20.4324 scb=0.0198648 scc=0.00175929 fw=2.4e-07 $X=57300 $Y=-20730 $dt=1
M109 118 115 11 11 g45p1svt w=2.4e-07 l=4.5e-08 ad=3.36e-14 as=3.36e-14 pd=7.6e-07 ps=7.6e-07 sa=1.4e-07 sb=1.4e-07 sca=20.4324 scb=0.0198648 scc=0.00175929 fw=2.4e-07 $X=57300 $Y=3600 $dt=1
M110 132 41 11 11 g45p1svt w=2.4e-07 l=4.5e-08 ad=3.36e-14 as=3.36e-14 pd=7.6e-07 ps=7.6e-07 sa=1.4e-07 sb=1.4e-07 sca=20.4324 scb=0.0198648 scc=0.00175929 fw=2.4e-07 $X=58550 $Y=-44700 $dt=1
M111 125 42 11 11 g45p1svt w=2.4e-07 l=4.5e-08 ad=3.36e-14 as=3.36e-14 pd=7.6e-07 ps=7.6e-07 sa=1.4e-07 sb=1.4e-07 sca=20.4324 scb=0.0198648 scc=0.00175929 fw=2.4e-07 $X=58550 $Y=-20730 $dt=1
M112 118 43 11 11 g45p1svt w=2.4e-07 l=4.5e-08 ad=3.36e-14 as=3.36e-14 pd=7.6e-07 ps=7.6e-07 sa=1.4e-07 sb=1.4e-07 sca=20.4324 scb=0.0198648 scc=0.00175929 fw=2.4e-07 $X=58550 $Y=3600 $dt=1
M113 52 112 268 11 g45p1svt w=4.8e-07 l=4.5e-08 ad=6.72e-14 as=6.72e-14 pd=1.24e-06 ps=1.24e-06 sa=1.4e-07 sb=1.4e-07 sca=8.67038 scb=0.00597621 scc=0.000178408 fw=4.8e-07 $X=60170 $Y=-28300 $dt=1
M114 49 132 11 11 g45p1svt w=2.4e-07 l=4.5e-08 ad=3.36e-14 as=3.36e-14 pd=7.6e-07 ps=7.6e-07 sa=1.4e-07 sb=1.4e-07 sca=20.4324 scb=0.0198648 scc=0.00175929 fw=2.4e-07 $X=60510 $Y=-44700 $dt=1
M115 46 125 11 11 g45p1svt w=2.4e-07 l=4.5e-08 ad=3.36e-14 as=3.36e-14 pd=7.6e-07 ps=7.6e-07 sa=1.4e-07 sb=1.4e-07 sca=20.4324 scb=0.0198648 scc=0.00175929 fw=2.4e-07 $X=60510 $Y=-20730 $dt=1
M116 45 118 11 11 g45p1svt w=2.4e-07 l=4.5e-08 ad=3.36e-14 as=3.36e-14 pd=7.6e-07 ps=7.6e-07 sa=1.4e-07 sb=1.4e-07 sca=20.4324 scb=0.0198648 scc=0.00175929 fw=2.4e-07 $X=60510 $Y=3600 $dt=1
M117 130 41 11 11 g45p1svt w=2.4e-07 l=4.5e-08 ad=3.36e-14 as=3.36e-14 pd=7.6e-07 ps=7.6e-07 sa=1.4e-07 sb=1.4e-07 sca=35.0507 scb=0.0256051 scc=0.00441982 fw=2.4e-07 $X=61290 $Y=-37210 $dt=1
M118 123 42 11 11 g45p1svt w=2.4e-07 l=4.5e-08 ad=3.36e-14 as=3.36e-14 pd=7.6e-07 ps=7.6e-07 sa=1.4e-07 sb=1.4e-07 sca=35.0507 scb=0.0256051 scc=0.00441982 fw=2.4e-07 $X=61290 $Y=-13240 $dt=1
M119 116 43 11 11 g45p1svt w=2.4e-07 l=4.5e-08 ad=3.36e-14 as=3.36e-14 pd=7.6e-07 ps=7.6e-07 sa=1.4e-07 sb=1.4e-07 sca=35.0507 scb=0.0256051 scc=0.00441982 fw=2.4e-07 $X=61290 $Y=11090 $dt=1
M120 49 133 11 11 g45p1svt w=2.4e-07 l=4.5e-08 ad=3.36e-14 as=3.36e-14 pd=7.6e-07 ps=7.6e-07 sa=1.4e-07 sb=1.4e-07 sca=25.5159 scb=0.0267815 scc=0.00187996 fw=2.4e-07 $X=61760 $Y=-44700 $dt=1
M121 46 126 11 11 g45p1svt w=2.4e-07 l=4.5e-08 ad=3.36e-14 as=3.36e-14 pd=7.6e-07 ps=7.6e-07 sa=1.4e-07 sb=1.4e-07 sca=25.5159 scb=0.0267815 scc=0.00187996 fw=2.4e-07 $X=61760 $Y=-20730 $dt=1
M122 45 119 11 11 g45p1svt w=2.4e-07 l=4.5e-08 ad=3.36e-14 as=3.36e-14 pd=7.6e-07 ps=7.6e-07 sa=1.4e-07 sb=1.4e-07 sca=25.5159 scb=0.0267815 scc=0.00187996 fw=2.4e-07 $X=61760 $Y=3600 $dt=1
M123 17 129 265 11 g45p1svt w=4.8e-07 l=4.5e-08 ad=6.72e-14 as=6.72e-14 pd=1.24e-06 ps=1.24e-06 sa=1.4e-07 sb=1.4e-07 sca=12.8218 scb=0.0114511 scc=0.000406405 fw=4.8e-07 $X=61790 $Y=-39220 $dt=1
M124 38 122 261 11 g45p1svt w=4.8e-07 l=4.5e-08 ad=6.72e-14 as=6.72e-14 pd=1.24e-06 ps=1.24e-06 sa=1.4e-07 sb=1.4e-07 sca=12.8218 scb=0.0114511 scc=0.000406405 fw=4.8e-07 $X=61790 $Y=-15250 $dt=1
M125 39 115 257 11 g45p1svt w=4.8e-07 l=4.5e-08 ad=6.72e-14 as=6.72e-14 pd=1.24e-06 ps=1.24e-06 sa=1.4e-07 sb=1.4e-07 sca=12.8218 scb=0.0114511 scc=0.000406405 fw=4.8e-07 $X=61790 $Y=9080 $dt=1
.ends Multiplier

* +++++++++++++++++++++++++++++++++++++++++++++++++++++++++ *
* Sub cell: proc_el                                         *
* +++++++++++++++++++++++++++++++++++++++++++++++++++++++++ *
.subckt proc_el 1 2 3 4 5 6 7 8 9 10
+ 11 12 13 14 15 16 17 18 19 20
+ 21 22 23 24 25 26 27 28 29 30
+ 31 32 33 34 35 36 37 38 39 40
+ 41 42 43 44 45 46 47 48 49 50
+ 51 52 53 54 55 56 57 58 59 60
+ 61 62 483
*.DEVICECLIMB
** N=549 EP=63 FDC=1025
X0 1 M2_M1_CDNS_1 $T=-66440 2060 0 0 $X=-66520 $Y=1930
X1 2 M2_M1_CDNS_1 $T=-66440 8440 0 0 $X=-66520 $Y=8310
X2 11 M2_M1_CDNS_1 $T=-66440 15060 0 0 $X=-66520 $Y=14930
X3 11 M2_M1_CDNS_1 $T=-66440 49350 0 0 $X=-66520 $Y=49220
X4 2 M2_M1_CDNS_1 $T=-66430 9680 0 0 $X=-66510 $Y=9550
X5 3 M2_M1_CDNS_1 $T=-66140 2460 0 0 $X=-66220 $Y=2330
X6 12 M2_M1_CDNS_1 $T=-66140 15820 0 0 $X=-66220 $Y=15690
X7 12 M2_M1_CDNS_1 $T=-66140 73720 0 0 $X=-66220 $Y=73590
X8 4 M2_M1_CDNS_1 $T=-65840 2860 0 0 $X=-65920 $Y=2730
X9 10 M2_M1_CDNS_1 $T=-65840 16520 0 0 $X=-65920 $Y=16390
X10 10 M2_M1_CDNS_1 $T=-65840 98050 0 0 $X=-65920 $Y=97920
X11 6 M2_M1_CDNS_1 $T=-65540 3260 0 0 $X=-65620 $Y=3130
X12 5 M2_M1_CDNS_1 $T=-65540 11650 0 0 $X=-65620 $Y=11520
X13 5 M2_M1_CDNS_1 $T=-65540 104170 0 0 $X=-65620 $Y=104040
X14 30 M2_M1_CDNS_1 $T=-65450 5720 0 0 $X=-65530 $Y=5590
X15 30 M2_M1_CDNS_1 $T=-65450 9310 0 0 $X=-65530 $Y=9180
X16 7 M2_M1_CDNS_1 $T=-65420 3900 0 0 $X=-65500 $Y=3770
X17 7 M2_M1_CDNS_1 $T=-65420 4970 0 0 $X=-65500 $Y=4840
X18 8 M2_M1_CDNS_1 $T=-65240 12390 0 0 $X=-65320 $Y=12260
X19 8 M2_M1_CDNS_1 $T=-65240 17640 0 0 $X=-65320 $Y=17510
X20 9 M2_M1_CDNS_1 $T=-65130 6570 0 0 $X=-65210 $Y=6440
X21 9 M2_M1_CDNS_1 $T=-65130 9740 0 0 $X=-65210 $Y=9610
X22 7 M2_M1_CDNS_1 $T=-61560 3910 0 0 $X=-61640 $Y=3780
X23 7 M2_M1_CDNS_1 $T=-61400 100200 0 0 $X=-61480 $Y=100070
X24 30 M2_M1_CDNS_1 $T=-61170 9300 0 0 $X=-61250 $Y=9170
X25 30 M2_M1_CDNS_1 $T=-61170 11620 0 0 $X=-61250 $Y=11490
X26 6 M2_M1_CDNS_1 $T=-58930 3260 0 0 $X=-59010 $Y=3130
X27 6 M2_M1_CDNS_1 $T=-58930 6100 0 0 $X=-59010 $Y=5970
X28 2 M2_M1_CDNS_1 $T=-57790 8430 0 0 $X=-57870 $Y=8300
X29 10 M2_M1_CDNS_1 $T=-57720 11650 0 0 $X=-57800 $Y=11520
X30 10 M2_M1_CDNS_1 $T=-57720 16520 0 0 $X=-57800 $Y=16390
X31 2 M2_M1_CDNS_1 $T=-57640 103460 0 0 $X=-57720 $Y=103330
X32 31 M2_M1_CDNS_1 $T=-57490 5720 0 0 $X=-57570 $Y=5590
X33 31 M2_M1_CDNS_1 $T=-57490 9310 0 0 $X=-57570 $Y=9180
X34 8 M2_M1_CDNS_1 $T=-57280 12390 0 0 $X=-57360 $Y=12260
X35 8 M2_M1_CDNS_1 $T=-57280 17640 0 0 $X=-57360 $Y=17510
X36 9 M2_M1_CDNS_1 $T=-57170 6570 0 0 $X=-57250 $Y=6440
X37 9 M2_M1_CDNS_1 $T=-57170 9740 0 0 $X=-57250 $Y=9610
X38 31 M2_M1_CDNS_1 $T=-53210 9300 0 0 $X=-53290 $Y=9170
X39 31 M2_M1_CDNS_1 $T=-53210 11620 0 0 $X=-53290 $Y=11490
X40 2 M2_M1_CDNS_1 $T=-53170 64690 0 0 $X=-53250 $Y=64560
X41 2 M2_M1_CDNS_1 $T=-53170 66020 0 0 $X=-53250 $Y=65890
X42 4 M2_M1_CDNS_1 $T=-50960 2860 0 0 $X=-51040 $Y=2730
X43 4 M2_M1_CDNS_1 $T=-50960 6100 0 0 $X=-51040 $Y=5970
X44 12 M2_M1_CDNS_1 $T=-49760 11650 0 0 $X=-49840 $Y=11520
X45 12 M2_M1_CDNS_1 $T=-49760 15820 0 0 $X=-49840 $Y=15690
X46 32 M2_M1_CDNS_1 $T=-49530 5720 0 0 $X=-49610 $Y=5590
X47 32 M2_M1_CDNS_1 $T=-49530 9310 0 0 $X=-49610 $Y=9180
X48 8 M2_M1_CDNS_1 $T=-49320 12390 0 0 $X=-49400 $Y=12260
X49 8 M2_M1_CDNS_1 $T=-49320 17640 0 0 $X=-49400 $Y=17510
X50 9 M2_M1_CDNS_1 $T=-49200 6570 0 0 $X=-49280 $Y=6440
X51 9 M2_M1_CDNS_1 $T=-49200 9740 0 0 $X=-49280 $Y=9610
X52 2 M2_M1_CDNS_1 $T=-47500 34740 0 0 $X=-47580 $Y=34610
X53 32 M2_M1_CDNS_1 $T=-45250 9300 0 0 $X=-45330 $Y=9170
X54 32 M2_M1_CDNS_1 $T=-45250 11620 0 0 $X=-45330 $Y=11490
X55 2 M2_M1_CDNS_1 $T=-44320 8430 0 0 $X=-44400 $Y=8300
X56 2 M2_M1_CDNS_1 $T=-44320 13660 0 0 $X=-44400 $Y=13530
X57 3 M2_M1_CDNS_1 $T=-43010 2460 0 0 $X=-43090 $Y=2330
X58 3 M2_M1_CDNS_1 $T=-43010 6100 0 0 $X=-43090 $Y=5970
X59 7 M2_M1_CDNS_1 $T=-42440 3910 0 0 $X=-42520 $Y=3780
X60 7 M2_M1_CDNS_1 $T=-42440 10330 0 0 $X=-42520 $Y=10200
X61 11 M2_M1_CDNS_1 $T=-41800 11640 0 0 $X=-41880 $Y=11510
X62 11 M2_M1_CDNS_1 $T=-41800 15060 0 0 $X=-41880 $Y=14930
X63 33 M2_M1_CDNS_1 $T=-41570 5720 0 0 $X=-41650 $Y=5590
X64 33 M2_M1_CDNS_1 $T=-41570 9310 0 0 $X=-41650 $Y=9180
X65 8 M2_M1_CDNS_1 $T=-41360 12390 0 0 $X=-41440 $Y=12260
X66 8 M2_M1_CDNS_1 $T=-41360 17640 0 0 $X=-41440 $Y=17510
X67 9 M2_M1_CDNS_1 $T=-41240 6570 0 0 $X=-41320 $Y=6440
X68 9 M2_M1_CDNS_1 $T=-41240 9740 0 0 $X=-41320 $Y=9610
X69 33 M2_M1_CDNS_1 $T=-37290 9300 0 0 $X=-37370 $Y=9170
X70 33 M2_M1_CDNS_1 $T=-37290 11620 0 0 $X=-37370 $Y=11490
X71 1 M2_M1_CDNS_1 $T=-35040 2060 0 0 $X=-35120 $Y=1930
X72 1 M2_M1_CDNS_1 $T=-35040 6100 0 0 $X=-35120 $Y=5970
X73 8 M2_M1_CDNS_1 $T=-34000 -1750 0 0 $X=-34080 $Y=-1880
X74 8 M2_M1_CDNS_1 $T=-34000 5720 0 0 $X=-34080 $Y=5590
X75 8 M2_M1_CDNS_1 $T=-34000 17640 0 0 $X=-34080 $Y=17510
X76 9 M2_M1_CDNS_1 $T=-33700 6570 0 0 $X=-33780 $Y=6440
X77 9 M2_M1_CDNS_1 $T=-33700 9740 0 0 $X=-33780 $Y=9610
X78 17 M2_M1_CDNS_1 $T=-27500 -1750 0 0 $X=-27580 $Y=-1880
X79 17 M2_M1_CDNS_1 $T=-27500 6100 0 0 $X=-27580 $Y=5970
X80 16 M2_M1_CDNS_1 $T=-27230 100750 0 0 $X=-27310 $Y=100620
X81 16 M2_M1_CDNS_1 $T=-27230 104570 0 0 $X=-27310 $Y=104440
X82 8 M2_M1_CDNS_1 $T=-26930 101480 0 0 $X=-27010 $Y=101350
X83 8 M2_M1_CDNS_1 $T=-26930 106160 0 0 $X=-27010 $Y=106030
X84 7 M2_M1_CDNS_1 $T=-26870 3890 0 0 $X=-26950 $Y=3760
X85 7 M2_M1_CDNS_1 $T=-26870 5070 0 0 $X=-26950 $Y=4940
X86 7 M2_M1_CDNS_1 $T=-26640 99380 0 0 $X=-26720 $Y=99250
X87 7 M2_M1_CDNS_1 $T=-26640 100210 0 0 $X=-26720 $Y=100080
X88 2 M2_M1_CDNS_1 $T=-26630 102700 0 0 $X=-26710 $Y=102570
X89 2 M2_M1_CDNS_1 $T=-26630 103530 0 0 $X=-26710 $Y=103400
X90 8 M2_M1_CDNS_1 $T=-26310 -1060 0 0 $X=-26390 $Y=-1190
X91 8 M2_M1_CDNS_1 $T=-26310 17640 0 0 $X=-26390 $Y=17510
X92 9 M2_M1_CDNS_1 $T=-26010 -660 0 0 $X=-26090 $Y=-790
X93 9 M2_M1_CDNS_1 $T=-26010 9740 0 0 $X=-26090 $Y=9610
X94 2 M2_M1_CDNS_1 $T=-25400 8420 0 0 $X=-25480 $Y=8290
X95 2 M2_M1_CDNS_1 $T=-25400 9520 0 0 $X=-25480 $Y=9390
X96 34 M2_M1_CDNS_1 $T=-24510 13840 0 0 $X=-24590 $Y=13710
X97 35 M2_M1_CDNS_1 $T=-24210 13240 0 0 $X=-24290 $Y=13110
X98 9 M2_M1_CDNS_1 $T=-22450 101560 0 0 $X=-22530 $Y=101430
X99 9 M2_M1_CDNS_1 $T=-22450 106560 0 0 $X=-22530 $Y=106430
X100 7 M2_M1_CDNS_1 $T=-16050 260 0 0 $X=-16130 $Y=130
X101 7 M2_M1_CDNS_1 $T=-16050 99150 0 0 $X=-16130 $Y=99020
X102 18 M2_M1_CDNS_1 $T=-15690 101080 0 0 $X=-15770 $Y=100950
X103 18 M2_M1_CDNS_1 $T=-15690 104570 0 0 $X=-15770 $Y=104440
X104 15 M2_M1_CDNS_1 $T=-15300 100750 0 0 $X=-15380 $Y=100620
X105 15 M2_M1_CDNS_1 $T=-15300 104970 0 0 $X=-15380 $Y=104840
X106 8 M2_M1_CDNS_1 $T=-15000 101480 0 0 $X=-15080 $Y=101350
X107 8 M2_M1_CDNS_1 $T=-15000 106160 0 0 $X=-15080 $Y=106030
X108 8 M2_M1_CDNS_1 $T=-11480 -1060 0 0 $X=-11560 $Y=-1190
X109 9 M2_M1_CDNS_1 $T=-11180 -660 0 0 $X=-11260 $Y=-790
X110 9 M2_M1_CDNS_1 $T=-10630 101560 0 0 $X=-10710 $Y=101430
X111 9 M2_M1_CDNS_1 $T=-10630 106560 0 0 $X=-10710 $Y=106430
X112 34 M2_M1_CDNS_1 $T=-8880 13840 0 0 $X=-8960 $Y=13710
X113 34 M2_M1_CDNS_1 $T=-8880 29500 0 0 $X=-8960 $Y=29370
X114 36 M2_M1_CDNS_1 $T=-8880 54050 0 0 $X=-8960 $Y=53920
X115 36 M2_M1_CDNS_1 $T=-8880 63380 0 0 $X=-8960 $Y=63250
X116 37 M2_M1_CDNS_1 $T=-8880 77470 0 0 $X=-8960 $Y=77340
X117 37 M2_M1_CDNS_1 $T=-8880 77960 0 0 $X=-8960 $Y=77830
X118 38 M2_M1_CDNS_1 $T=-8880 91560 0 0 $X=-8960 $Y=91430
X119 38 M2_M1_CDNS_1 $T=-8880 98360 0 0 $X=-8960 $Y=98230
X120 39 M2_M1_CDNS_1 $T=-8870 30840 0 0 $X=-8950 $Y=30710
X121 39 M2_M1_CDNS_1 $T=-8870 49290 0 0 $X=-8950 $Y=49160
X122 40 M2_M1_CDNS_1 $T=-8570 30530 0 0 $X=-8650 $Y=30400
X123 40 M2_M1_CDNS_1 $T=-8570 35210 0 0 $X=-8650 $Y=35080
X124 41 M2_M1_CDNS_1 $T=-8270 21120 0 0 $X=-8350 $Y=20990
X125 41 M2_M1_CDNS_1 $T=-8270 30220 0 0 $X=-8350 $Y=30090
X126 42 M2_M1_CDNS_1 $T=-7970 13840 0 0 $X=-8050 $Y=13710
X127 42 M2_M1_CDNS_1 $T=-7970 29910 0 0 $X=-8050 $Y=29780
X128 2 M2_M1_CDNS_1 $T=-7490 3500 0 0 $X=-7570 $Y=3370
X129 2 M2_M1_CDNS_1 $T=-7490 103450 0 0 $X=-7570 $Y=103320
X130 20 M2_M1_CDNS_1 $T=-3870 -1420 0 0 $X=-3950 $Y=-1550
X131 20 M2_M1_CDNS_1 $T=-3870 1420 0 0 $X=-3950 $Y=1290
X132 19 M2_M1_CDNS_1 $T=-3870 101080 0 0 $X=-3950 $Y=100950
X133 19 M2_M1_CDNS_1 $T=-3870 104970 0 0 $X=-3950 $Y=104840
X134 14 M2_M1_CDNS_1 $T=-3480 100750 0 0 $X=-3560 $Y=100620
X135 14 M2_M1_CDNS_1 $T=-3480 105360 0 0 $X=-3560 $Y=105230
X136 35 M2_M1_CDNS_1 $T=-3220 -260 0 0 $X=-3300 $Y=-390
X137 35 M2_M1_CDNS_1 $T=-3220 13240 0 0 $X=-3300 $Y=13110
X138 8 M2_M1_CDNS_1 $T=-3180 101480 0 0 $X=-3260 $Y=101350
X139 8 M2_M1_CDNS_1 $T=-3180 106160 0 0 $X=-3260 $Y=106030
X140 7 M2_M1_CDNS_1 $T=-2860 260 0 0 $X=-2940 $Y=130
X141 7 M2_M1_CDNS_1 $T=-2860 99470 0 0 $X=-2940 $Y=99340
X142 42 M2_M1_CDNS_1 $T=-2580 13830 0 0 $X=-2660 $Y=13700
X143 7 M2_M1_CDNS_1 $T=-2280 97170 0 0 $X=-2360 $Y=97040
X144 9 M2_M1_CDNS_1 $T=1190 101560 0 0 $X=1110 $Y=101430
X145 9 M2_M1_CDNS_1 $T=1190 106560 0 0 $X=1110 $Y=106430
X146 7 M2_M1_CDNS_1 $T=2340 12640 0 0 $X=2260 $Y=12510
X147 7 M2_M1_CDNS_1 $T=2340 14300 0 0 $X=2260 $Y=14170
X148 7 M2_M1_CDNS_1 $T=2340 26720 0 0 $X=2260 $Y=26590
X149 7 M2_M1_CDNS_1 $T=2340 28380 0 0 $X=2260 $Y=28250
X150 7 M2_M1_CDNS_1 $T=2340 40820 0 0 $X=2260 $Y=40690
X151 7 M2_M1_CDNS_1 $T=2340 42480 0 0 $X=2260 $Y=42350
X152 7 M2_M1_CDNS_1 $T=2340 54900 0 0 $X=2260 $Y=54770
X153 7 M2_M1_CDNS_1 $T=2340 56560 0 0 $X=2260 $Y=56430
X154 7 M2_M1_CDNS_1 $T=2340 69010 0 0 $X=2260 $Y=68880
X155 7 M2_M1_CDNS_1 $T=2340 70670 0 0 $X=2260 $Y=70540
X156 7 M2_M1_CDNS_1 $T=2340 83110 0 0 $X=2260 $Y=82980
X157 7 M2_M1_CDNS_1 $T=2340 84770 0 0 $X=2260 $Y=84640
X158 2 M2_M1_CDNS_1 $T=2380 3560 0 0 $X=2300 $Y=3430
X159 2 M2_M1_CDNS_1 $T=2380 103450 0 0 $X=2300 $Y=103320
X160 7 M2_M1_CDNS_1 $T=6070 97230 0 0 $X=5990 $Y=97100
X161 7 M2_M1_CDNS_1 $T=6070 98900 0 0 $X=5990 $Y=98770
X162 21 M2_M1_CDNS_1 $T=7950 101080 0 0 $X=7870 $Y=100950
X163 21 M2_M1_CDNS_1 $T=7950 105370 0 0 $X=7870 $Y=105240
X164 13 M2_M1_CDNS_1 $T=8340 100750 0 0 $X=8260 $Y=100620
X165 13 M2_M1_CDNS_1 $T=8340 105760 0 0 $X=8260 $Y=105630
X166 8 M2_M1_CDNS_1 $T=8640 97700 0 0 $X=8560 $Y=97570
X167 8 M2_M1_CDNS_1 $T=8640 101480 0 0 $X=8560 $Y=101350
X168 8 M2_M1_CDNS_1 $T=8640 106160 0 0 $X=8560 $Y=106030
X169 8 M2_M1_CDNS_1 $T=10450 -1060 0 0 $X=10370 $Y=-1190
X170 8 M2_M1_CDNS_1 $T=10450 97700 0 0 $X=10370 $Y=97570
X171 9 M2_M1_CDNS_1 $T=10750 -660 0 0 $X=10670 $Y=-790
X172 9 M2_M1_CDNS_1 $T=10750 97700 0 0 $X=10670 $Y=97570
X173 9 M2_M1_CDNS_1 $T=10750 106560 0 0 $X=10670 $Y=106430
X174 2 M2_M1_CDNS_1 $T=11470 94110 0 0 $X=11390 $Y=93980
X175 2 M2_M1_CDNS_1 $T=11480 102710 0 0 $X=11400 $Y=102580
X176 9 M2_M1_CDNS_1 $T=13010 97700 0 0 $X=12930 $Y=97570
X177 9 M2_M1_CDNS_1 $T=13010 101560 0 0 $X=12930 $Y=101430
X178 9 M2_M1_CDNS_1 $T=13010 106560 0 0 $X=12930 $Y=106430
X179 2 M2_M1_CDNS_1 $T=14420 9610 0 0 $X=14340 $Y=9480
X180 2 M2_M1_CDNS_1 $T=14420 17580 0 0 $X=14340 $Y=17450
X181 2 M2_M1_CDNS_1 $T=14420 23690 0 0 $X=14340 $Y=23560
X182 2 M2_M1_CDNS_1 $T=14420 31660 0 0 $X=14340 $Y=31530
X183 2 M2_M1_CDNS_1 $T=14420 37790 0 0 $X=14340 $Y=37660
X184 2 M2_M1_CDNS_1 $T=14420 45760 0 0 $X=14340 $Y=45630
X185 2 M2_M1_CDNS_1 $T=14420 51870 0 0 $X=14340 $Y=51740
X186 2 M2_M1_CDNS_1 $T=14420 59840 0 0 $X=14340 $Y=59710
X187 2 M2_M1_CDNS_1 $T=14420 65980 0 0 $X=14340 $Y=65850
X188 2 M2_M1_CDNS_1 $T=14420 73950 0 0 $X=14340 $Y=73820
X189 2 M2_M1_CDNS_1 $T=14420 80080 0 0 $X=14340 $Y=79950
X190 2 M2_M1_CDNS_1 $T=14420 88050 0 0 $X=14340 $Y=87920
X191 7 M2_M1_CDNS_1 $T=19320 98890 0 0 $X=19240 $Y=98760
X192 7 M2_M1_CDNS_1 $T=19320 100210 0 0 $X=19240 $Y=100080
X193 22 M2_M1_CDNS_1 $T=19770 101080 0 0 $X=19690 $Y=100950
X194 22 M2_M1_CDNS_1 $T=19770 105770 0 0 $X=19690 $Y=105640
X195 2 7 30 9 43 6 178 484 485 379
+ 380 FlipFlop $T=-62060 4010 0 0 $X=-65470 $Y=3610
X196 2 7 31 9 44 4 180 486 487 382
+ 383 FlipFlop $T=-54100 4010 0 0 $X=-57510 $Y=3610
X197 2 7 32 9 45 3 182 488 489 385
+ 386 FlipFlop $T=-46140 4010 0 0 $X=-49550 $Y=3610
X198 2 7 33 9 46 1 184 490 491 388
+ 389 FlipFlop $T=-38180 4010 0 0 $X=-41590 $Y=3610
X199 2 7 8 9 47 17 185 492 493 390
+ 391 FlipFlop $T=-30640 4010 0 0 $X=-34050 $Y=3610
X200 2 7 48 9 49 18 199 500 501 403
+ 404 FlipFlop $T=-19180 99000 0 0 $X=-22590 $Y=98600
X201 2 7 50 9 51 19 201 502 503 406
+ 407 FlipFlop $T=-7360 99000 0 0 $X=-10770 $Y=98600
X202 2 7 52 9 53 21 287 546 547 479
+ 480 FlipFlop $T=4460 99000 0 0 $X=1050 $Y=98600
X203 2 7 54 9 55 22 289 548 549 482
+ 483 FlipFlop $T=16280 99000 0 0 $X=12870 $Y=98600
X204 20 35 56 7 2 34 8 9 194 195
+ 198 197 188 193 196 494 499 faabs $T=-11740 200 0 0 $X=-25550 $Y=-1240
X205 23 57 35 7 2 42 8 9 281 282
+ 285 284 275 280 283 540 545 faabs $T=10190 200 0 0 $X=-3620 $Y=-1240
X206 24 58 57 7 2 41 8 9 269 270
+ 273 272 263 268 271 534 539 faabs $T=10190 14290 0 0 $X=-3620 $Y=12850
X207 25 59 58 7 2 40 8 9 257 258
+ 261 260 251 256 259 528 533 faabs $T=10190 28380 0 0 $X=-3620 $Y=26940
X208 26 60 59 7 2 39 8 9 245 246
+ 249 248 239 244 247 522 527 faabs $T=10190 42460 0 0 $X=-3620 $Y=41020
X209 27 61 60 7 2 36 8 9 233 234
+ 237 236 227 232 235 516 521 faabs $T=10190 56550 0 0 $X=-3620 $Y=55110
X210 28 62 61 7 2 37 8 9 221 222
+ 225 224 215 220 223 510 515 faabs $T=10190 70640 0 0 $X=-3620 $Y=69200
X211 29 7 62 7 2 38 8 9 209 210
+ 213 212 203 208 211 504 509 faabs $T=10190 84730 0 0 $X=-3620 $Y=83290
X212 2 7 5 8 30 177 378 AND $T=-62430 9930 0 0 $X=-65470 $Y=10080
X213 2 7 10 8 31 179 381 AND $T=-54470 9930 0 0 $X=-57510 $Y=10080
X214 2 7 12 8 32 181 384 AND $T=-46510 9930 0 0 $X=-49550 $Y=10080
X215 2 7 11 8 33 183 387 AND $T=-38550 9920 0 0 $X=-41590 $Y=10070
X216 2 7 16 8 48 186 392 AND $T=-23900 99020 0 0 $X=-26940 $Y=99170
X217 2 7 15 8 50 200 405 AND $T=-11970 99020 0 0 $X=-15010 $Y=99170
X218 2 7 14 8 52 286 408 AND $T=-150 99020 0 0 $X=-3190 $Y=99170
X219 2 7 13 8 54 288 481 AND $T=11670 99020 0 0 $X=8630 $Y=99170
X220 16 15 14 13 5 10 12 11 38 7
+ 2 39 37 36 40 41 42 34 71 64
+ 77 76 69 68 102 81 80 79 87 86
+ 85 134 133 132 114 113 112 120 119 118
+ 167 166 165 146 145 152 151 150 157 101
+ 100 371 Multiplier $T=-72890 78510 0 0 $X=-65460 $Y=29370
M0 6 9 380 7 g45n1svt w=2.4e-07 l=4.5e-08 ad=3.36e-14 as=3.36e-14 pd=7.6e-07 ps=7.6e-07 sa=1.4e-07 sb=1.4e-07 sca=3.52678 scb=0.000111658 scc=3.66286e-09 fw=2.4e-07 $X=-59740 $Y=4520 $dt=0
M1 4 9 383 7 g45n1svt w=2.4e-07 l=4.5e-08 ad=3.36e-14 as=3.36e-14 pd=7.6e-07 ps=7.6e-07 sa=1.4e-07 sb=1.4e-07 sca=3.52678 scb=0.000111658 scc=3.66286e-09 fw=2.4e-07 $X=-51780 $Y=4520 $dt=0
M2 3 9 386 7 g45n1svt w=2.4e-07 l=4.5e-08 ad=3.36e-14 as=3.36e-14 pd=7.6e-07 ps=7.6e-07 sa=1.4e-07 sb=1.4e-07 sca=3.52678 scb=0.000111658 scc=3.66286e-09 fw=2.4e-07 $X=-43820 $Y=4520 $dt=0
M3 1 9 389 7 g45n1svt w=2.4e-07 l=4.5e-08 ad=3.36e-14 as=3.36e-14 pd=7.6e-07 ps=7.6e-07 sa=1.4e-07 sb=1.4e-07 sca=3.52678 scb=0.000111658 scc=3.66286e-09 fw=2.4e-07 $X=-35860 $Y=4520 $dt=0
M4 17 9 391 7 g45n1svt w=2.4e-07 l=4.5e-08 ad=3.36e-14 as=3.36e-14 pd=7.6e-07 ps=7.6e-07 sa=1.4e-07 sb=1.4e-07 sca=3.52678 scb=0.000111658 scc=3.66286e-09 fw=2.4e-07 $X=-28320 $Y=4520 $dt=0
M5 18 9 404 7 g45n1svt w=2.4e-07 l=4.5e-08 ad=3.36e-14 as=3.36e-14 pd=7.6e-07 ps=7.6e-07 sa=1.4e-07 sb=1.4e-07 sca=3.52678 scb=0.000111658 scc=3.66286e-09 fw=2.4e-07 $X=-16860 $Y=99510 $dt=0
M6 19 9 407 7 g45n1svt w=2.4e-07 l=4.5e-08 ad=3.36e-14 as=3.36e-14 pd=7.6e-07 ps=7.6e-07 sa=1.4e-07 sb=1.4e-07 sca=3.52678 scb=0.000111658 scc=3.66286e-09 fw=2.4e-07 $X=-5040 $Y=99510 $dt=0
M7 21 9 480 7 g45n1svt w=2.4e-07 l=4.5e-08 ad=3.36e-14 as=3.36e-14 pd=7.6e-07 ps=7.6e-07 sa=1.4e-07 sb=1.4e-07 sca=3.52678 scb=0.000111658 scc=3.66286e-09 fw=2.4e-07 $X=6780 $Y=99510 $dt=0
M8 178 9 2 2 g45p1svt w=2.4e-07 l=4.5e-08 ad=3.36e-14 as=3.36e-14 pd=7.6e-07 ps=7.6e-07 sa=1.4e-07 sb=1.4e-07 sca=15.0576 scb=0.0142053 scc=0.000386892 fw=2.4e-07 $X=-64560 $Y=7170 $dt=1
M9 177 8 2 2 g45p1svt w=2.4e-07 l=4.5e-08 ad=3.36e-14 as=3.36e-14 pd=7.6e-07 ps=7.6e-07 sa=1.4e-07 sb=1.4e-07 sca=16.0927 scb=0.0154531 scc=0.000419743 fw=2.4e-07 $X=-64540 $Y=12700 $dt=1
M10 484 30 2 2 g45p1svt w=4.8e-07 l=4.5e-08 ad=6.72e-14 as=6.72e-14 pd=1.24e-06 ps=1.24e-06 sa=1.4e-07 sb=1.4e-07 sca=16.1286 scb=0.0134283 scc=0.00129853 fw=4.8e-07 $X=-63320 $Y=6920 $dt=1
M11 43 9 484 2 g45p1svt w=4.8e-07 l=4.5e-08 ad=6.72e-14 as=6.72e-14 pd=1.24e-06 ps=1.24e-06 sa=1.4e-07 sb=1.4e-07 sca=15.6391 scb=0.0131208 scc=0.00120734 fw=4.8e-07 $X=-62110 $Y=6930 $dt=1
M12 30 177 2 2 g45p1svt w=2.4e-07 l=4.5e-08 ad=3.36e-14 as=3.36e-14 pd=7.6e-07 ps=7.6e-07 sa=1.4e-07 sb=1.4e-07 sca=12.8329 scb=0.0117498 scc=0.000390557 fw=2.4e-07 $X=-62010 $Y=12700 $dt=1
M13 485 43 2 2 g45p1svt w=4.8e-07 l=4.5e-08 ad=6.72e-14 as=6.72e-14 pd=1.24e-06 ps=1.24e-06 sa=1.4e-07 sb=1.4e-07 sca=16.1286 scb=0.0134283 scc=0.00129853 fw=4.8e-07 $X=-60920 $Y=6920 $dt=1
M14 6 178 485 2 g45p1svt w=4.8e-07 l=4.5e-08 ad=6.72e-14 as=6.72e-14 pd=1.24e-06 ps=1.24e-06 sa=1.4e-07 sb=1.4e-07 sca=15.6391 scb=0.0131208 scc=0.00120734 fw=4.8e-07 $X=-59740 $Y=6930 $dt=1
M15 180 9 2 2 g45p1svt w=2.4e-07 l=4.5e-08 ad=3.36e-14 as=3.36e-14 pd=7.6e-07 ps=7.6e-07 sa=1.4e-07 sb=1.4e-07 sca=11.619 scb=0.0101937 scc=0.000351981 fw=2.4e-07 $X=-56600 $Y=7170 $dt=1
M16 179 8 2 2 g45p1svt w=2.4e-07 l=4.5e-08 ad=3.36e-14 as=3.36e-14 pd=7.6e-07 ps=7.6e-07 sa=1.4e-07 sb=1.4e-07 sca=12.8329 scb=0.0117498 scc=0.000390557 fw=2.4e-07 $X=-56580 $Y=12700 $dt=1
M17 486 31 2 2 g45p1svt w=4.8e-07 l=4.5e-08 ad=6.72e-14 as=6.72e-14 pd=1.24e-06 ps=1.24e-06 sa=1.4e-07 sb=1.4e-07 sca=16.1286 scb=0.0134283 scc=0.00129853 fw=4.8e-07 $X=-55360 $Y=6920 $dt=1
M18 44 9 486 2 g45p1svt w=4.8e-07 l=4.5e-08 ad=6.72e-14 as=6.72e-14 pd=1.24e-06 ps=1.24e-06 sa=1.4e-07 sb=1.4e-07 sca=15.6391 scb=0.0131208 scc=0.00120734 fw=4.8e-07 $X=-54150 $Y=6930 $dt=1
M19 31 179 2 2 g45p1svt w=2.4e-07 l=4.5e-08 ad=3.36e-14 as=3.36e-14 pd=7.6e-07 ps=7.6e-07 sa=1.4e-07 sb=1.4e-07 sca=12.8329 scb=0.0117498 scc=0.000390557 fw=2.4e-07 $X=-54050 $Y=12700 $dt=1
M20 487 44 2 2 g45p1svt w=4.8e-07 l=4.5e-08 ad=6.72e-14 as=6.72e-14 pd=1.24e-06 ps=1.24e-06 sa=1.4e-07 sb=1.4e-07 sca=16.1286 scb=0.0134283 scc=0.00129853 fw=4.8e-07 $X=-52960 $Y=6920 $dt=1
M21 4 180 487 2 g45p1svt w=4.8e-07 l=4.5e-08 ad=6.72e-14 as=6.72e-14 pd=1.24e-06 ps=1.24e-06 sa=1.4e-07 sb=1.4e-07 sca=15.6391 scb=0.0131208 scc=0.00120734 fw=4.8e-07 $X=-51780 $Y=6930 $dt=1
M22 182 9 2 2 g45p1svt w=2.4e-07 l=4.5e-08 ad=3.36e-14 as=3.36e-14 pd=7.6e-07 ps=7.6e-07 sa=1.4e-07 sb=1.4e-07 sca=11.619 scb=0.0101937 scc=0.000351981 fw=2.4e-07 $X=-48640 $Y=7170 $dt=1
M23 181 8 2 2 g45p1svt w=2.4e-07 l=4.5e-08 ad=3.36e-14 as=3.36e-14 pd=7.6e-07 ps=7.6e-07 sa=1.4e-07 sb=1.4e-07 sca=12.8329 scb=0.0117498 scc=0.000390557 fw=2.4e-07 $X=-48620 $Y=12700 $dt=1
M24 488 32 2 2 g45p1svt w=4.8e-07 l=4.5e-08 ad=6.72e-14 as=6.72e-14 pd=1.24e-06 ps=1.24e-06 sa=1.4e-07 sb=1.4e-07 sca=16.1286 scb=0.0134283 scc=0.00129853 fw=4.8e-07 $X=-47400 $Y=6920 $dt=1
M25 45 9 488 2 g45p1svt w=4.8e-07 l=4.5e-08 ad=6.72e-14 as=6.72e-14 pd=1.24e-06 ps=1.24e-06 sa=1.4e-07 sb=1.4e-07 sca=15.6391 scb=0.0131208 scc=0.00120734 fw=4.8e-07 $X=-46190 $Y=6930 $dt=1
M26 32 181 2 2 g45p1svt w=2.4e-07 l=4.5e-08 ad=3.36e-14 as=3.36e-14 pd=7.6e-07 ps=7.6e-07 sa=1.4e-07 sb=1.4e-07 sca=12.8329 scb=0.0117498 scc=0.000390557 fw=2.4e-07 $X=-46090 $Y=12700 $dt=1
M27 489 45 2 2 g45p1svt w=4.8e-07 l=4.5e-08 ad=6.72e-14 as=6.72e-14 pd=1.24e-06 ps=1.24e-06 sa=1.4e-07 sb=1.4e-07 sca=16.1286 scb=0.0134283 scc=0.00129853 fw=4.8e-07 $X=-45000 $Y=6920 $dt=1
M28 3 182 489 2 g45p1svt w=4.8e-07 l=4.5e-08 ad=6.72e-14 as=6.72e-14 pd=1.24e-06 ps=1.24e-06 sa=1.4e-07 sb=1.4e-07 sca=15.6391 scb=0.0131208 scc=0.00120734 fw=4.8e-07 $X=-43820 $Y=6930 $dt=1
M29 184 9 2 2 g45p1svt w=2.4e-07 l=4.5e-08 ad=3.36e-14 as=3.36e-14 pd=7.6e-07 ps=7.6e-07 sa=1.4e-07 sb=1.4e-07 sca=11.619 scb=0.0101937 scc=0.000351981 fw=2.4e-07 $X=-40680 $Y=7170 $dt=1
M30 183 8 2 2 g45p1svt w=2.4e-07 l=4.5e-08 ad=3.36e-14 as=3.36e-14 pd=7.6e-07 ps=7.6e-07 sa=1.4e-07 sb=1.4e-07 sca=12.8329 scb=0.0117498 scc=0.000390557 fw=2.4e-07 $X=-40660 $Y=12690 $dt=1
M31 490 33 2 2 g45p1svt w=4.8e-07 l=4.5e-08 ad=6.72e-14 as=6.72e-14 pd=1.24e-06 ps=1.24e-06 sa=1.4e-07 sb=1.4e-07 sca=16.1286 scb=0.0134283 scc=0.00129853 fw=4.8e-07 $X=-39440 $Y=6920 $dt=1
M32 46 9 490 2 g45p1svt w=4.8e-07 l=4.5e-08 ad=6.72e-14 as=6.72e-14 pd=1.24e-06 ps=1.24e-06 sa=1.4e-07 sb=1.4e-07 sca=15.6391 scb=0.0131208 scc=0.00120734 fw=4.8e-07 $X=-38230 $Y=6930 $dt=1
M33 33 183 2 2 g45p1svt w=2.4e-07 l=4.5e-08 ad=3.36e-14 as=3.36e-14 pd=7.6e-07 ps=7.6e-07 sa=1.4e-07 sb=1.4e-07 sca=15.9246 scb=0.0151668 scc=0.000414946 fw=2.4e-07 $X=-38130 $Y=12690 $dt=1
M34 491 46 2 2 g45p1svt w=4.8e-07 l=4.5e-08 ad=6.72e-14 as=6.72e-14 pd=1.24e-06 ps=1.24e-06 sa=1.4e-07 sb=1.4e-07 sca=16.1286 scb=0.0134283 scc=0.00129853 fw=4.8e-07 $X=-37040 $Y=6920 $dt=1
M35 1 184 491 2 g45p1svt w=4.8e-07 l=4.5e-08 ad=6.72e-14 as=6.72e-14 pd=1.24e-06 ps=1.24e-06 sa=1.4e-07 sb=1.4e-07 sca=15.6391 scb=0.0131208 scc=0.00120734 fw=4.8e-07 $X=-35860 $Y=6930 $dt=1
M36 185 9 2 2 g45p1svt w=2.4e-07 l=4.5e-08 ad=3.36e-14 as=3.36e-14 pd=7.6e-07 ps=7.6e-07 sa=1.4e-07 sb=1.4e-07 sca=11.619 scb=0.0101937 scc=0.000351981 fw=2.4e-07 $X=-33140 $Y=7170 $dt=1
M37 492 8 2 2 g45p1svt w=4.8e-07 l=4.5e-08 ad=6.72e-14 as=6.72e-14 pd=1.24e-06 ps=1.24e-06 sa=1.4e-07 sb=1.4e-07 sca=16.1286 scb=0.0134283 scc=0.00129853 fw=4.8e-07 $X=-31900 $Y=6920 $dt=1
M38 47 9 492 2 g45p1svt w=4.8e-07 l=4.5e-08 ad=6.72e-14 as=6.72e-14 pd=1.24e-06 ps=1.24e-06 sa=1.4e-07 sb=1.4e-07 sca=15.6391 scb=0.0131208 scc=0.00120734 fw=4.8e-07 $X=-30690 $Y=6930 $dt=1
M39 493 47 2 2 g45p1svt w=4.8e-07 l=4.5e-08 ad=6.72e-14 as=6.72e-14 pd=1.24e-06 ps=1.24e-06 sa=1.4e-07 sb=1.4e-07 sca=16.1286 scb=0.0134283 scc=0.00129853 fw=4.8e-07 $X=-29500 $Y=6920 $dt=1
M40 17 185 493 2 g45p1svt w=4.8e-07 l=4.5e-08 ad=6.72e-14 as=6.72e-14 pd=1.24e-06 ps=1.24e-06 sa=1.4e-07 sb=1.4e-07 sca=18.4233 scb=0.0160258 scc=0.00122435 fw=4.8e-07 $X=-28320 $Y=6930 $dt=1
M41 186 8 2 2 g45p1svt w=2.4e-07 l=4.5e-08 ad=3.36e-14 as=3.36e-14 pd=7.6e-07 ps=7.6e-07 sa=1.4e-07 sb=1.4e-07 sca=14.8024 scb=0.0139872 scc=0.00040819 fw=2.4e-07 $X=-26010 $Y=101790 $dt=1
M42 193 20 2 2 g45p1svt w=2.4e-07 l=4.5e-08 ad=3.36e-14 as=3.36e-14 pd=7.6e-07 ps=7.6e-07 sa=1.4e-07 sb=1.4e-07 sca=15.0046 scb=0.0138563 scc=0.000630427 fw=2.4e-07 $X=-23870 $Y=2600 $dt=1
M43 494 20 2 2 g45p1svt w=4.8e-07 l=4.5e-08 ad=6.72e-14 as=6.72e-14 pd=1.24e-06 ps=1.24e-06 sa=1.4e-07 sb=1.4e-07 sca=9.68014 scb=0.0076467 scc=0.00037449 fw=4.8e-07 $X=-23740 $Y=8080 $dt=1
M44 188 34 2 2 g45p1svt w=2.4e-07 l=4.5e-08 ad=3.36e-14 as=3.36e-14 pd=7.6e-07 ps=7.6e-07 sa=1.4e-07 sb=1.4e-07 sca=34.3359 scb=0.0252032 scc=0.0044195 fw=2.4e-07 $X=-23730 $Y=10090 $dt=1
M45 48 186 2 2 g45p1svt w=2.4e-07 l=4.5e-08 ad=3.36e-14 as=3.36e-14 pd=7.6e-07 ps=7.6e-07 sa=1.4e-07 sb=1.4e-07 sca=12.8329 scb=0.0117498 scc=0.000390557 fw=2.4e-07 $X=-23480 $Y=101790 $dt=1
M46 199 9 2 2 g45p1svt w=2.4e-07 l=4.5e-08 ad=3.36e-14 as=3.36e-14 pd=7.6e-07 ps=7.6e-07 sa=1.4e-07 sb=1.4e-07 sca=11.619 scb=0.0101937 scc=0.000351981 fw=2.4e-07 $X=-21680 $Y=102160 $dt=1
M47 500 48 2 2 g45p1svt w=4.8e-07 l=4.5e-08 ad=6.72e-14 as=6.72e-14 pd=1.24e-06 ps=1.24e-06 sa=1.4e-07 sb=1.4e-07 sca=16.1286 scb=0.0134283 scc=0.00129853 fw=4.8e-07 $X=-20440 $Y=101910 $dt=1
M48 49 9 500 2 g45p1svt w=4.8e-07 l=4.5e-08 ad=6.72e-14 as=6.72e-14 pd=1.24e-06 ps=1.24e-06 sa=1.4e-07 sb=1.4e-07 sca=15.6391 scb=0.0131208 scc=0.00120734 fw=4.8e-07 $X=-19230 $Y=101920 $dt=1
M49 501 49 2 2 g45p1svt w=4.8e-07 l=4.5e-08 ad=6.72e-14 as=6.72e-14 pd=1.24e-06 ps=1.24e-06 sa=1.4e-07 sb=1.4e-07 sca=16.1286 scb=0.0134283 scc=0.00129853 fw=4.8e-07 $X=-18040 $Y=101910 $dt=1
M50 18 199 501 2 g45p1svt w=4.8e-07 l=4.5e-08 ad=6.72e-14 as=6.72e-14 pd=1.24e-06 ps=1.24e-06 sa=1.4e-07 sb=1.4e-07 sca=15.6391 scb=0.0131208 scc=0.00120734 fw=4.8e-07 $X=-16860 $Y=101920 $dt=1
M51 200 8 2 2 g45p1svt w=2.4e-07 l=4.5e-08 ad=3.36e-14 as=3.36e-14 pd=7.6e-07 ps=7.6e-07 sa=1.4e-07 sb=1.4e-07 sca=12.8329 scb=0.0117498 scc=0.000390557 fw=2.4e-07 $X=-14080 $Y=101790 $dt=1
M52 50 200 2 2 g45p1svt w=2.4e-07 l=4.5e-08 ad=3.36e-14 as=3.36e-14 pd=7.6e-07 ps=7.6e-07 sa=1.4e-07 sb=1.4e-07 sca=12.8329 scb=0.0117498 scc=0.000390557 fw=2.4e-07 $X=-11550 $Y=101790 $dt=1
M53 201 9 2 2 g45p1svt w=2.4e-07 l=4.5e-08 ad=3.36e-14 as=3.36e-14 pd=7.6e-07 ps=7.6e-07 sa=1.4e-07 sb=1.4e-07 sca=11.619 scb=0.0101937 scc=0.000351981 fw=2.4e-07 $X=-9860 $Y=102160 $dt=1
M54 502 50 2 2 g45p1svt w=4.8e-07 l=4.5e-08 ad=6.72e-14 as=6.72e-14 pd=1.24e-06 ps=1.24e-06 sa=1.4e-07 sb=1.4e-07 sca=16.1286 scb=0.0134283 scc=0.00129853 fw=4.8e-07 $X=-8620 $Y=101910 $dt=1
M55 51 9 502 2 g45p1svt w=4.8e-07 l=4.5e-08 ad=6.72e-14 as=6.72e-14 pd=1.24e-06 ps=1.24e-06 sa=1.4e-07 sb=1.4e-07 sca=15.6391 scb=0.0131208 scc=0.00120734 fw=4.8e-07 $X=-7410 $Y=101920 $dt=1
M56 503 51 2 2 g45p1svt w=4.8e-07 l=4.5e-08 ad=6.72e-14 as=6.72e-14 pd=1.24e-06 ps=1.24e-06 sa=1.4e-07 sb=1.4e-07 sca=16.1286 scb=0.0134283 scc=0.00129853 fw=4.8e-07 $X=-6220 $Y=101910 $dt=1
M57 198 196 499 2 g45p1svt w=4.8e-07 l=4.5e-08 ad=6.72e-14 as=6.72e-14 pd=1.24e-06 ps=1.24e-06 sa=1.4e-07 sb=1.4e-07 sca=13.3978 scb=0.0114602 scc=0.001037 fw=4.8e-07 $X=-5120 $Y=8100 $dt=1
M58 19 201 503 2 g45p1svt w=4.8e-07 l=4.5e-08 ad=6.72e-14 as=6.72e-14 pd=1.24e-06 ps=1.24e-06 sa=1.4e-07 sb=1.4e-07 sca=15.6391 scb=0.0131208 scc=0.00120734 fw=4.8e-07 $X=-5040 $Y=101920 $dt=1
M59 286 8 2 2 g45p1svt w=2.4e-07 l=4.5e-08 ad=3.36e-14 as=3.36e-14 pd=7.6e-07 ps=7.6e-07 sa=1.4e-07 sb=1.4e-07 sca=12.8329 scb=0.0117498 scc=0.000390557 fw=2.4e-07 $X=-2260 $Y=101790 $dt=1
M60 280 23 2 2 g45p1svt w=2.4e-07 l=4.5e-08 ad=3.36e-14 as=3.36e-14 pd=7.6e-07 ps=7.6e-07 sa=1.4e-07 sb=1.4e-07 sca=13.9617 scb=0.0132915 scc=0.000629907 fw=2.4e-07 $X=-1940 $Y=2600 $dt=1
M61 268 24 2 2 g45p1svt w=2.4e-07 l=4.5e-08 ad=3.36e-14 as=3.36e-14 pd=7.6e-07 ps=7.6e-07 sa=1.4e-07 sb=1.4e-07 sca=15.0046 scb=0.0138563 scc=0.000630427 fw=2.4e-07 $X=-1940 $Y=16690 $dt=1
M62 256 25 2 2 g45p1svt w=2.4e-07 l=4.5e-08 ad=3.36e-14 as=3.36e-14 pd=7.6e-07 ps=7.6e-07 sa=1.4e-07 sb=1.4e-07 sca=15.0046 scb=0.0138563 scc=0.000630427 fw=2.4e-07 $X=-1940 $Y=30780 $dt=1
M63 244 26 2 2 g45p1svt w=2.4e-07 l=4.5e-08 ad=3.36e-14 as=3.36e-14 pd=7.6e-07 ps=7.6e-07 sa=1.4e-07 sb=1.4e-07 sca=15.0046 scb=0.0138563 scc=0.000630427 fw=2.4e-07 $X=-1940 $Y=44860 $dt=1
M64 232 27 2 2 g45p1svt w=2.4e-07 l=4.5e-08 ad=3.36e-14 as=3.36e-14 pd=7.6e-07 ps=7.6e-07 sa=1.4e-07 sb=1.4e-07 sca=15.0046 scb=0.0138563 scc=0.000630427 fw=2.4e-07 $X=-1940 $Y=58950 $dt=1
M65 220 28 2 2 g45p1svt w=2.4e-07 l=4.5e-08 ad=3.36e-14 as=3.36e-14 pd=7.6e-07 ps=7.6e-07 sa=1.4e-07 sb=1.4e-07 sca=15.0046 scb=0.0138563 scc=0.000630427 fw=2.4e-07 $X=-1940 $Y=73040 $dt=1
M66 208 29 2 2 g45p1svt w=2.4e-07 l=4.5e-08 ad=3.36e-14 as=3.36e-14 pd=7.6e-07 ps=7.6e-07 sa=1.4e-07 sb=1.4e-07 sca=15.0046 scb=0.0138563 scc=0.000630427 fw=2.4e-07 $X=-1940 $Y=87130 $dt=1
M67 540 23 2 2 g45p1svt w=4.8e-07 l=4.5e-08 ad=6.72e-14 as=6.72e-14 pd=1.24e-06 ps=1.24e-06 sa=1.4e-07 sb=1.4e-07 sca=9.47395 scb=0.00759651 scc=0.000374483 fw=4.8e-07 $X=-1810 $Y=8080 $dt=1
M68 534 24 2 2 g45p1svt w=4.8e-07 l=4.5e-08 ad=6.72e-14 as=6.72e-14 pd=1.24e-06 ps=1.24e-06 sa=1.4e-07 sb=1.4e-07 sca=9.68014 scb=0.0076467 scc=0.00037449 fw=4.8e-07 $X=-1810 $Y=22170 $dt=1
M69 528 25 2 2 g45p1svt w=4.8e-07 l=4.5e-08 ad=6.72e-14 as=6.72e-14 pd=1.24e-06 ps=1.24e-06 sa=1.4e-07 sb=1.4e-07 sca=9.68014 scb=0.0076467 scc=0.00037449 fw=4.8e-07 $X=-1810 $Y=36260 $dt=1
M70 522 26 2 2 g45p1svt w=4.8e-07 l=4.5e-08 ad=6.72e-14 as=6.72e-14 pd=1.24e-06 ps=1.24e-06 sa=1.4e-07 sb=1.4e-07 sca=9.68014 scb=0.0076467 scc=0.00037449 fw=4.8e-07 $X=-1810 $Y=50340 $dt=1
M71 516 27 2 2 g45p1svt w=4.8e-07 l=4.5e-08 ad=6.72e-14 as=6.72e-14 pd=1.24e-06 ps=1.24e-06 sa=1.4e-07 sb=1.4e-07 sca=9.68014 scb=0.0076467 scc=0.00037449 fw=4.8e-07 $X=-1810 $Y=64430 $dt=1
M72 510 28 2 2 g45p1svt w=4.8e-07 l=4.5e-08 ad=6.72e-14 as=6.72e-14 pd=1.24e-06 ps=1.24e-06 sa=1.4e-07 sb=1.4e-07 sca=9.68014 scb=0.0076467 scc=0.00037449 fw=4.8e-07 $X=-1810 $Y=78520 $dt=1
M73 504 29 2 2 g45p1svt w=4.8e-07 l=4.5e-08 ad=6.72e-14 as=6.72e-14 pd=1.24e-06 ps=1.24e-06 sa=1.4e-07 sb=1.4e-07 sca=9.68014 scb=0.0076467 scc=0.00037449 fw=4.8e-07 $X=-1810 $Y=92610 $dt=1
M74 275 42 2 2 g45p1svt w=2.4e-07 l=4.5e-08 ad=3.36e-14 as=3.36e-14 pd=7.6e-07 ps=7.6e-07 sa=1.4e-07 sb=1.4e-07 sca=34.1422 scb=0.0251568 scc=0.00441949 fw=2.4e-07 $X=-1800 $Y=10090 $dt=1
M75 263 41 2 2 g45p1svt w=2.4e-07 l=4.5e-08 ad=3.36e-14 as=3.36e-14 pd=7.6e-07 ps=7.6e-07 sa=1.4e-07 sb=1.4e-07 sca=34.3359 scb=0.0252032 scc=0.0044195 fw=2.4e-07 $X=-1800 $Y=24180 $dt=1
M76 251 40 2 2 g45p1svt w=2.4e-07 l=4.5e-08 ad=3.36e-14 as=3.36e-14 pd=7.6e-07 ps=7.6e-07 sa=1.4e-07 sb=1.4e-07 sca=34.3359 scb=0.0252032 scc=0.0044195 fw=2.4e-07 $X=-1800 $Y=38270 $dt=1
M77 239 39 2 2 g45p1svt w=2.4e-07 l=4.5e-08 ad=3.36e-14 as=3.36e-14 pd=7.6e-07 ps=7.6e-07 sa=1.4e-07 sb=1.4e-07 sca=34.3359 scb=0.0252032 scc=0.0044195 fw=2.4e-07 $X=-1800 $Y=52350 $dt=1
M78 227 36 2 2 g45p1svt w=2.4e-07 l=4.5e-08 ad=3.36e-14 as=3.36e-14 pd=7.6e-07 ps=7.6e-07 sa=1.4e-07 sb=1.4e-07 sca=34.3359 scb=0.0252032 scc=0.0044195 fw=2.4e-07 $X=-1800 $Y=66440 $dt=1
M79 215 37 2 2 g45p1svt w=2.4e-07 l=4.5e-08 ad=3.36e-14 as=3.36e-14 pd=7.6e-07 ps=7.6e-07 sa=1.4e-07 sb=1.4e-07 sca=34.3359 scb=0.0252032 scc=0.0044195 fw=2.4e-07 $X=-1800 $Y=80530 $dt=1
M80 203 38 2 2 g45p1svt w=2.4e-07 l=4.5e-08 ad=3.36e-14 as=3.36e-14 pd=7.6e-07 ps=7.6e-07 sa=1.4e-07 sb=1.4e-07 sca=34.3359 scb=0.0252032 scc=0.0044195 fw=2.4e-07 $X=-1800 $Y=94620 $dt=1
M81 52 286 2 2 g45p1svt w=2.4e-07 l=4.5e-08 ad=3.36e-14 as=3.36e-14 pd=7.6e-07 ps=7.6e-07 sa=1.4e-07 sb=1.4e-07 sca=12.8329 scb=0.0117498 scc=0.000390557 fw=2.4e-07 $X=270 $Y=101790 $dt=1
M82 287 9 2 2 g45p1svt w=2.4e-07 l=4.5e-08 ad=3.36e-14 as=3.36e-14 pd=7.6e-07 ps=7.6e-07 sa=1.4e-07 sb=1.4e-07 sca=11.619 scb=0.0101937 scc=0.000351981 fw=2.4e-07 $X=1960 $Y=102160 $dt=1
M83 546 52 2 2 g45p1svt w=4.8e-07 l=4.5e-08 ad=6.72e-14 as=6.72e-14 pd=1.24e-06 ps=1.24e-06 sa=1.4e-07 sb=1.4e-07 sca=16.1286 scb=0.0134283 scc=0.00129853 fw=4.8e-07 $X=3200 $Y=101910 $dt=1
M84 53 9 546 2 g45p1svt w=4.8e-07 l=4.5e-08 ad=6.72e-14 as=6.72e-14 pd=1.24e-06 ps=1.24e-06 sa=1.4e-07 sb=1.4e-07 sca=15.6391 scb=0.0131208 scc=0.00120734 fw=4.8e-07 $X=4410 $Y=101920 $dt=1
M85 547 53 2 2 g45p1svt w=4.8e-07 l=4.5e-08 ad=6.72e-14 as=6.72e-14 pd=1.24e-06 ps=1.24e-06 sa=1.4e-07 sb=1.4e-07 sca=16.1286 scb=0.0134283 scc=0.00129853 fw=4.8e-07 $X=5600 $Y=101910 $dt=1
M86 21 287 547 2 g45p1svt w=4.8e-07 l=4.5e-08 ad=6.72e-14 as=6.72e-14 pd=1.24e-06 ps=1.24e-06 sa=1.4e-07 sb=1.4e-07 sca=15.6391 scb=0.0131208 scc=0.00120734 fw=4.8e-07 $X=6780 $Y=101920 $dt=1
M87 288 8 2 2 g45p1svt w=2.4e-07 l=4.5e-08 ad=3.36e-14 as=3.36e-14 pd=7.6e-07 ps=7.6e-07 sa=1.4e-07 sb=1.4e-07 sca=12.8329 scb=0.0117498 scc=0.000390557 fw=2.4e-07 $X=9560 $Y=101790 $dt=1
M88 54 288 2 2 g45p1svt w=2.4e-07 l=4.5e-08 ad=3.36e-14 as=3.36e-14 pd=7.6e-07 ps=7.6e-07 sa=1.4e-07 sb=1.4e-07 sca=12.8329 scb=0.0117498 scc=0.000390557 fw=2.4e-07 $X=12090 $Y=101790 $dt=1
M89 289 9 2 2 g45p1svt w=2.4e-07 l=4.5e-08 ad=3.36e-14 as=3.36e-14 pd=7.6e-07 ps=7.6e-07 sa=1.4e-07 sb=1.4e-07 sca=11.619 scb=0.0101937 scc=0.000351981 fw=2.4e-07 $X=13780 $Y=102160 $dt=1
M90 548 54 2 2 g45p1svt w=4.8e-07 l=4.5e-08 ad=6.72e-14 as=6.72e-14 pd=1.24e-06 ps=1.24e-06 sa=1.4e-07 sb=1.4e-07 sca=16.1286 scb=0.0134283 scc=0.00129853 fw=4.8e-07 $X=15020 $Y=101910 $dt=1
M91 55 9 548 2 g45p1svt w=4.8e-07 l=4.5e-08 ad=6.72e-14 as=6.72e-14 pd=1.24e-06 ps=1.24e-06 sa=1.4e-07 sb=1.4e-07 sca=15.6391 scb=0.0131208 scc=0.00120734 fw=4.8e-07 $X=16230 $Y=101920 $dt=1
M92 285 283 545 2 g45p1svt w=4.8e-07 l=4.5e-08 ad=6.72e-14 as=6.72e-14 pd=1.24e-06 ps=1.24e-06 sa=1.4e-07 sb=1.4e-07 sca=13.9023 scb=0.0116351 scc=0.00103705 fw=4.8e-07 $X=16810 $Y=8100 $dt=1
M93 273 271 539 2 g45p1svt w=4.8e-07 l=4.5e-08 ad=6.72e-14 as=6.72e-14 pd=1.24e-06 ps=1.24e-06 sa=1.4e-07 sb=1.4e-07 sca=13.9023 scb=0.0116351 scc=0.00103705 fw=4.8e-07 $X=16810 $Y=22190 $dt=1
M94 261 259 533 2 g45p1svt w=4.8e-07 l=4.5e-08 ad=6.72e-14 as=6.72e-14 pd=1.24e-06 ps=1.24e-06 sa=1.4e-07 sb=1.4e-07 sca=13.9023 scb=0.0116351 scc=0.00103705 fw=4.8e-07 $X=16810 $Y=36280 $dt=1
M95 249 247 527 2 g45p1svt w=4.8e-07 l=4.5e-08 ad=6.72e-14 as=6.72e-14 pd=1.24e-06 ps=1.24e-06 sa=1.4e-07 sb=1.4e-07 sca=13.9023 scb=0.0116351 scc=0.00103705 fw=4.8e-07 $X=16810 $Y=50360 $dt=1
M96 237 235 521 2 g45p1svt w=4.8e-07 l=4.5e-08 ad=6.72e-14 as=6.72e-14 pd=1.24e-06 ps=1.24e-06 sa=1.4e-07 sb=1.4e-07 sca=13.9023 scb=0.0116351 scc=0.00103705 fw=4.8e-07 $X=16810 $Y=64450 $dt=1
M97 225 223 515 2 g45p1svt w=4.8e-07 l=4.5e-08 ad=6.72e-14 as=6.72e-14 pd=1.24e-06 ps=1.24e-06 sa=1.4e-07 sb=1.4e-07 sca=13.9023 scb=0.0116351 scc=0.00103705 fw=4.8e-07 $X=16810 $Y=78540 $dt=1
M98 213 211 509 2 g45p1svt w=4.8e-07 l=4.5e-08 ad=6.72e-14 as=6.72e-14 pd=1.24e-06 ps=1.24e-06 sa=1.4e-07 sb=1.4e-07 sca=13.9023 scb=0.0116351 scc=0.00103705 fw=4.8e-07 $X=16810 $Y=92630 $dt=1
M99 549 55 2 2 g45p1svt w=4.8e-07 l=4.5e-08 ad=6.72e-14 as=6.72e-14 pd=1.24e-06 ps=1.24e-06 sa=1.4e-07 sb=1.4e-07 sca=16.1286 scb=0.0134283 scc=0.00129853 fw=4.8e-07 $X=17420 $Y=101910 $dt=1
M100 22 289 549 2 g45p1svt w=4.8e-07 l=4.5e-08 ad=6.72e-14 as=6.72e-14 pd=1.24e-06 ps=1.24e-06 sa=1.4e-07 sb=1.4e-07 sca=18.4233 scb=0.0160258 scc=0.00122435 fw=4.8e-07 $X=18600 $Y=101920 $dt=1
.ends proc_el

* +++++++++++++++++++++++++++++++++++++++++++++++++++++++++ *
* Sub cell: MASCO__A1                                       *
* +++++++++++++++++++++++++++++++++++++++++++++++++++++++++ *
.subckt MASCO__A1 1 2 3 4 5 6 7 8 9 10
+ 11 12 13 14 15 16 17 18 19 20
+ 21 22 23 24 25 26 27 28 29 30
+ 31 32 33 34 35 36 37 38 39 40
+ 41 42 43 44 45 46 47 48 49 50
+ 958
*.DEVICECLIMB
** N=958 EP=51 FDC=2051
X0 35 5 36 37 1 38 12 6 7 2
+ 4 3 8 9 10 11 13 47 48 21
+ 49 50 20 19 18 17 16 15 14 51
+ 70 89 112 152 174 214 213 212 215 216
+ 217 218 61 74 92 115 137 166 170 199
+ 203 227 243 293 309 676 249 248 247 246
+ 245 244 763 proc_el $T=66960 2110 0 0 $X=0 $Y=0
X1 39 5 40 41 22 42 12 13 7 23
+ 25 24 50 49 48 47 26 43 44 34
+ 45 46 33 32 31 30 29 28 27 310
+ 329 348 371 411 433 473 472 471 474 475
+ 476 477 320 333 351 374 396 425 429 458
+ 462 486 502 552 568 871 508 507 506 505
+ 504 503 958 proc_el $T=154140 2110 0 0 $X=87180 $Y=0
M0 50 7 763 12 g45n1svt w=2.4e-07 l=4.5e-08 ad=3.36e-14 as=3.36e-14 pd=7.6e-07 ps=7.6e-07 sa=1.4e-07 sb=1.4e-07 sca=3.52678 scb=0.000111658 scc=3.66286e-09 fw=2.4e-07 $X=85560 $Y=101620 $dt=0
.ends MASCO__A1

* +++++++++++++++++++++++++++++++++++++++++++++++++++++++++ *
* Sub cell: sys_arr_unp                                     *
* +++++++++++++++++++++++++++++++++++++++++++++++++++++++++ *
.subckt sys_arr_unp 123 122 121 120 89 88 87 86 56 55
+ 54 53 13 12 11 10 115 116 117 118
+ 132 133 134 135 247 248 249 250 260 261
+ 262 263 14 9 119 124 125 126 127 128
+ 129 130 131 90 91 92 93 94 95 96
+ 97 57 58 59 60 61 62 63 64 16
+ 17 18 19 20 21 22 23 137 138 139
+ 140 141 142 143 144 103 104 105 106 107
+ 108 109 110 70 71 72 73 74 75 76
+ 77 29 30 31 32 33 34 35 36 252
+ 253 254 255 256 257 258 259 222 223 224
+ 225 226 227 228 229 192 193 194 195 196
+ 197 198 199 154 155 156 157 158 159 160
+ 161 265 266 267 268 269 270 271 272 235
+ 236 237 238 239 240 241 242 205 206 207
+ 208 209 210 211 212 167 168 169 170 171
+ 172 173 174 8
** N=7572 EP=164 FDC=16416
X0 1 M2_M1_CDNS_1 $T=-11720 -217620 0 0 $X=-11800 $Y=-217750
X1 2 M2_M1_CDNS_1 $T=-11720 -108890 0 0 $X=-11800 $Y=-109020
X2 3 M2_M1_CDNS_1 $T=-11720 -160 0 0 $X=-11800 $Y=-290
X3 4 5 6 7 8 1 9 10 11 12
+ 13 14 15 16 17 18 19 20 21 22
+ 23 24 25 26 27 28 29 30 31 32
+ 33 34 35 36 37 38 39 40 41 42
+ 43 44 45 46 47 48 541 557 579 626
+ 4842 MASCO__A1 $T=-87320 -326710 0 0 $X=-87320 $Y=-326710
X4 49 50 51 52 8 2 9 53 54 55
+ 56 14 1 57 58 59 60 61 62 63
+ 64 65 66 67 68 69 70 71 72 73
+ 74 75 76 77 7 6 5 4 27 26
+ 25 24 78 79 80 81 1063 1079 1101 1148
+ 5232 MASCO__A1 $T=-87320 -217980 0 0 $X=-87320 $Y=-217980
X5 82 83 84 85 8 3 9 86 87 88
+ 89 14 2 90 91 92 93 94 95 96
+ 97 98 99 100 101 102 103 104 105 106
+ 107 108 109 110 52 51 50 49 68 67
+ 66 65 111 112 113 114 1585 1601 1623 1670
+ 5622 MASCO__A1 $T=-87320 -109250 0 0 $X=-87320 $Y=-109250
X6 115 116 117 118 8 119 9 120 121 122
+ 123 14 3 124 125 126 127 128 129 130
+ 131 132 133 134 135 136 137 138 139 140
+ 141 142 143 144 85 84 83 82 101 100
+ 99 98 145 146 147 148 2107 2123 2145 2192
+ 6012 MASCO__A1 $T=-87320 -520 0 0 $X=-87320 $Y=-520
X7 149 150 151 152 8 28 9 48 47 46
+ 45 14 153 154 155 156 157 158 159 160
+ 161 162 163 164 165 166 167 168 169 170
+ 171 172 173 174 175 176 177 178 179 180
+ 181 182 183 184 185 186 2629 2645 2667 2714
+ 6402 MASCO__A1 $T=87040 -326710 0 0 $X=87040 $Y=-326710
X8 187 188 189 190 8 69 9 81 80 79
+ 78 14 191 192 193 194 195 196 197 198
+ 199 200 201 202 203 204 205 206 207 208
+ 209 210 211 212 152 151 150 149 165 164
+ 163 162 213 214 215 216 3151 3167 3189 3236
+ 6792 MASCO__A1 $T=87040 -217980 0 0 $X=87040 $Y=-217980
X9 217 218 219 220 8 102 9 114 113 112
+ 111 14 221 222 223 224 225 226 227 228
+ 229 230 231 232 233 234 235 236 237 238
+ 239 240 241 242 190 189 188 187 203 202
+ 201 200 243 244 245 246 3673 3689 3711 3758
+ 7182 MASCO__A1 $T=87040 -109250 0 0 $X=87040 $Y=-109250
X10 247 248 249 250 8 136 9 148 147 146
+ 145 14 251 252 253 254 255 256 257 258
+ 259 260 261 262 263 264 265 266 267 268
+ 269 270 271 272 220 219 218 217 233 232
+ 231 230 273 274 275 276 4195 4211 4233 4280
+ 7572 MASCO__A1 $T=87040 -520 0 0 $X=87040 $Y=-520
M0 48 9 4842 14 g45n1svt w=2.4e-07 l=4.5e-08 ad=3.36e-14 as=3.36e-14 pd=7.6e-07 ps=7.6e-07 sa=1.4e-07 sb=1.4e-07 sca=3.52678 scb=0.000111658 scc=3.66286e-09 fw=2.4e-07 $X=85420 $Y=-225090 $dt=0
M1 81 9 5232 14 g45n1svt w=2.4e-07 l=4.5e-08 ad=3.36e-14 as=3.36e-14 pd=7.6e-07 ps=7.6e-07 sa=1.4e-07 sb=1.4e-07 sca=3.52678 scb=0.000111658 scc=3.66286e-09 fw=2.4e-07 $X=85420 $Y=-116360 $dt=0
M2 114 9 5622 14 g45n1svt w=2.4e-07 l=4.5e-08 ad=3.36e-14 as=3.36e-14 pd=7.6e-07 ps=7.6e-07 sa=1.4e-07 sb=1.4e-07 sca=3.52678 scb=0.000111658 scc=3.66286e-09 fw=2.4e-07 $X=85420 $Y=-7630 $dt=0
M3 148 9 6012 14 g45n1svt w=2.4e-07 l=4.5e-08 ad=3.36e-14 as=3.36e-14 pd=7.6e-07 ps=7.6e-07 sa=1.4e-07 sb=1.4e-07 sca=3.52678 scb=0.000111658 scc=3.66286e-09 fw=2.4e-07 $X=85420 $Y=101100 $dt=0
M4 186 9 6402 14 g45n1svt w=2.4e-07 l=4.5e-08 ad=3.36e-14 as=3.36e-14 pd=7.6e-07 ps=7.6e-07 sa=1.4e-07 sb=1.4e-07 sca=3.96308 scb=0.000252284 scc=4.02703e-08 fw=2.4e-07 $X=259780 $Y=-225090 $dt=0
M5 216 9 6792 14 g45n1svt w=2.4e-07 l=4.5e-08 ad=3.36e-14 as=3.36e-14 pd=7.6e-07 ps=7.6e-07 sa=1.4e-07 sb=1.4e-07 sca=3.96308 scb=0.000252284 scc=4.02703e-08 fw=2.4e-07 $X=259780 $Y=-116360 $dt=0
M6 246 9 7182 14 g45n1svt w=2.4e-07 l=4.5e-08 ad=3.36e-14 as=3.36e-14 pd=7.6e-07 ps=7.6e-07 sa=1.4e-07 sb=1.4e-07 sca=3.96308 scb=0.000252284 scc=4.02703e-08 fw=2.4e-07 $X=259780 $Y=-7630 $dt=0
M7 276 9 7572 14 g45n1svt w=2.4e-07 l=4.5e-08 ad=3.36e-14 as=3.36e-14 pd=7.6e-07 ps=7.6e-07 sa=1.4e-07 sb=1.4e-07 sca=3.96308 scb=0.000252284 scc=4.02703e-08 fw=2.4e-07 $X=259780 $Y=101100 $dt=0
.ends sys_arr_unp
