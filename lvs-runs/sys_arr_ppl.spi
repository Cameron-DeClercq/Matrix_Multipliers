* +++++++++++++++++++++++++++++++++++++++++++++++++++++++++ *
* CDL Netlist:                                              *
*                                                           *
* Cell Name  : sys_arr_ppl                                  *
* Netlisted  : Thu May 15 10:15:18 2025                     *
* Pegasus Version: 22.20-p009 Wed Jan 18 17:06:09 PST 2023  *
* +++++++++++++++++++++++++++++++++++++++++++++++++++++++++ *
*.LDD
*.DEVTMPLT 0 M(g45n1svt) _nmos1v ndiff_conn(D) poly_conn(G) ndiff_conn(S) psubstrate(B)
*.DEVTMPLT 1 M(g45p1svt) _pmos1v pdiff_conn(D) poly_conn(G) pdiff_conn(S) nwell_conn(B)

* +++++++++++++++++++++++++++++++++++++++++++++++++++++++++ *
* Sub cell: nmos1v_CDNS_10                                  *
* +++++++++++++++++++++++++++++++++++++++++++++++++++++++++ *
.subckt nmos1v_CDNS_10 S_source_0 D_drain_1 3
** N=3 EP=3 FDC=1
M0 D_drain_1 3 S_source_0 S_source_0 g45n1svt w=1.2e-07 l=4.5e-08 ad=1.68e-14 as=1.68e-14 pd=5.2e-07 ps=5.2e-07 sa=1.4e-07 sb=1.4e-07 sca=3.69959 scb=0.00013007 scc=4.39142e-09 fw=1.2e-07 $X=0 $Y=0 $dt=0
.ends nmos1v_CDNS_10

* +++++++++++++++++++++++++++++++++++++++++++++++++++++++++ *
* Sub cell: FlipFlop                                        *
* +++++++++++++++++++++++++++++++++++++++++++++++++++++++++ *
.subckt FlipFlop VDD GND A PHI Y 6 7 8 9 11
*.DEVICECLIMB
** N=11 EP=10 FDC=4
X45 GND 6 PHI nmos1v_CDNS_10 $T=-2500 640 0 0 $X=-2920 $Y=440
M0 10 A GND GND g45n1svt w=2.4e-07 l=4.5e-08 ad=3.36e-14 as=3.36e-14 pd=7.6e-07 ps=7.6e-07 sa=1.4e-07 sb=1.4e-07 sca=3.52678 scb=0.000111658 scc=3.66286e-09 fw=2.4e-07 $X=-1260 $Y=510 $dt=0
M1 7 6 10 GND g45n1svt w=2.4e-07 l=4.5e-08 ad=3.36e-14 as=3.36e-14 pd=7.6e-07 ps=7.6e-07 sa=1.4e-07 sb=1.4e-07 sca=3.52678 scb=0.000111658 scc=3.66286e-09 fw=2.4e-07 $X=-50 $Y=510 $dt=0
M2 11 7 GND GND g45n1svt w=2.4e-07 l=4.5e-08 ad=3.36e-14 as=3.36e-14 pd=7.6e-07 ps=7.6e-07 sa=1.4e-07 sb=1.4e-07 sca=3.52678 scb=0.000111658 scc=3.66286e-09 fw=2.4e-07 $X=1140 $Y=510 $dt=0
.ends FlipFlop

* +++++++++++++++++++++++++++++++++++++++++++++++++++++++++ *
* Sub cell: NAND                                            *
* +++++++++++++++++++++++++++++++++++++++++++++++++++++++++ *
.subckt NAND VDD GND Y B A
*.DEVICECLIMB
** N=6 EP=5 FDC=2
M0 6 A GND GND g45n1svt w=2.4e-07 l=4.5e-08 ad=3.36e-14 as=3.36e-14 pd=7.6e-07 ps=7.6e-07 sa=1.4e-07 sb=1.4e-07 sca=3.52678 scb=0.000111658 scc=3.66286e-09 fw=2.4e-07 $X=-1580 $Y=-500 $dt=0
M1 Y B 6 GND g45n1svt w=2.4e-07 l=4.5e-08 ad=3.36e-14 as=3.36e-14 pd=7.6e-07 ps=7.6e-07 sa=1.4e-07 sb=1.4e-07 sca=3.52678 scb=0.000111658 scc=3.66286e-09 fw=2.4e-07 $X=-330 $Y=-500 $dt=0
.ends NAND

* +++++++++++++++++++++++++++++++++++++++++++++++++++++++++ *
* Sub cell: XOR                                             *
* +++++++++++++++++++++++++++++++++++++++++++++++++++++++++ *
.subckt XOR B A GND VDD Y 6 7 8 9
*.DEVICECLIMB
** N=11 EP=9 FDC=8
X58 GND 7 A nmos1v_CDNS_10 $T=-1600 6860 0 0 $X=-2020 $Y=6660
X59 GND 6 B nmos1v_CDNS_10 $T=2060 6860 0 0 $X=1640 $Y=6660
M0 10 6 GND GND g45n1svt w=2.4e-07 l=4.5e-08 ad=3.36e-14 as=3.36e-14 pd=7.6e-07 ps=7.6e-07 sa=1.4e-07 sb=1.4e-07 sca=3.52678 scb=0.000111658 scc=3.66286e-09 fw=2.4e-07 $X=-1610 $Y=610 $dt=0
M1 Y 7 10 GND g45n1svt w=2.4e-07 l=4.5e-08 ad=3.36e-14 as=3.36e-14 pd=7.6e-07 ps=7.6e-07 sa=1.4e-07 sb=1.4e-07 sca=3.52678 scb=0.000111658 scc=3.66286e-09 fw=2.4e-07 $X=-190 $Y=610 $dt=0
M2 11 B GND GND g45n1svt w=2.4e-07 l=4.5e-08 ad=3.36e-14 as=3.36e-14 pd=7.6e-07 ps=7.6e-07 sa=1.4e-07 sb=1.4e-07 sca=3.52678 scb=0.000111658 scc=3.66286e-09 fw=2.4e-07 $X=1190 $Y=610 $dt=0
M3 Y A 11 GND g45n1svt w=2.4e-07 l=4.5e-08 ad=3.36e-14 as=3.36e-14 pd=7.6e-07 ps=7.6e-07 sa=1.4e-07 sb=1.4e-07 sca=3.52678 scb=0.000111658 scc=3.66286e-09 fw=2.4e-07 $X=2560 $Y=610 $dt=0
M4 Y 7 8 VDD g45p1svt w=4.8e-07 l=4.5e-08 ad=6.72e-14 as=6.72e-14 pd=1.24e-06 ps=1.24e-06 sa=1.4e-07 sb=1.4e-07 sca=9.47395 scb=0.00759651 scc=0.000374483 fw=4.8e-07 $X=-190 $Y=3090 $dt=1
M5 9 6 VDD VDD g45p1svt w=4.8e-07 l=4.5e-08 ad=6.72e-14 as=6.72e-14 pd=1.24e-06 ps=1.24e-06 sa=1.4e-07 sb=1.4e-07 sca=9.47395 scb=0.00759651 scc=0.000374483 fw=4.8e-07 $X=1190 $Y=3090 $dt=1
.ends XOR

* +++++++++++++++++++++++++++++++++++++++++++++++++++++++++ *
* Sub cell: Full_Adder                                      *
* +++++++++++++++++++++++++++++++++++++++++++++++++++++++++ *
.subckt Full_Adder B A CIN GND VDD SUM COUT 8 9 10
+ 12 13 22 25
*.DEVICECLIMB
** N=25 EP=14 FDC=26
X16 B A GND VDD 9 11 12 22 23 XOR $T=-6580 4190 0 0 $X=-9990 $Y=3980
X17 CIN 9 GND VDD SUM 13 14 24 25 XOR $T=230 4190 0 0 $X=-3180 $Y=3980
X18 VDD GND 8 A B NAND $T=-6740 420 0 0 $X=-9060 $Y=-820
X19 VDD GND 10 CIN 9 NAND $T=-120 420 0 0 $X=-2440 $Y=-820
X20 VDD GND COUT 8 10 NAND $T=3090 420 0 0 $X=770 $Y=-820
M0 11 B VDD VDD g45p1svt w=2.4e-07 l=4.5e-08 ad=3.36e-14 as=3.36e-14 pd=7.6e-07 ps=7.6e-07 sa=1.4e-07 sb=1.4e-07 sca=34.1422 scb=0.0251568 scc=0.00441949 fw=2.4e-07 $X=-4520 $Y=9290 $dt=1
M1 9 A 23 VDD g45p1svt w=4.8e-07 l=4.5e-08 ad=6.72e-14 as=6.72e-14 pd=1.24e-06 ps=1.24e-06 sa=1.4e-07 sb=1.4e-07 sca=9.47395 scb=0.00759651 scc=0.000374483 fw=4.8e-07 $X=-4020 $Y=7280 $dt=1
M2 24 CIN VDD VDD g45p1svt w=4.8e-07 l=4.5e-08 ad=6.72e-14 as=6.72e-14 pd=1.24e-06 ps=1.24e-06 sa=1.4e-07 sb=1.4e-07 sca=9.47395 scb=0.00759651 scc=0.000374483 fw=4.8e-07 $X=-1380 $Y=7280 $dt=1
M3 14 9 VDD VDD g45p1svt w=2.4e-07 l=4.5e-08 ad=3.36e-14 as=3.36e-14 pd=7.6e-07 ps=7.6e-07 sa=1.4e-07 sb=1.4e-07 sca=34.1422 scb=0.0251568 scc=0.00441949 fw=2.4e-07 $X=-1370 $Y=9290 $dt=1
.ends Full_Adder

* +++++++++++++++++++++++++++++++++++++++++++++++++++++++++ *
* Sub cell: inv                                             *
* +++++++++++++++++++++++++++++++++++++++++++++++++++++++++ *
.subckt inv VDD GND A Y
** N=4 EP=4 FDC=2
X11 GND Y A nmos1v_CDNS_10 $T=-90 135 0 0 $X=-510 $Y=-65
M0 Y A VDD VDD g45p1svt w=2.4e-07 l=4.5e-08 ad=3.36e-14 as=3.36e-14 pd=7.6e-07 ps=7.6e-07 sa=1.4e-07 sb=1.4e-07 sca=27.9284 scb=0.0232624 scc=0.00337691 fw=2.4e-07 $X=-90 $Y=1620 $dt=1
.ends inv

* +++++++++++++++++++++++++++++++++++++++++++++++++++++++++ *
* Sub cell: faabs                                           *
* +++++++++++++++++++++++++++++++++++++++++++++++++++++++++ *
.subckt faabs SOUT CIN COUT GND VDD A RST PHI 11 13
+ 18 19 31 36
*.DEVICECLIMB
** N=36 EP=14 FDC=48
X19 VDD GND 10 PHI 11 19 20 35 36 30 FlipFlop $T=4300 4980 0 0 $X=890 $Y=4580
X20 VDD GND 10 9 RST NAND $T=3320 930 0 0 $X=1000 $Y=-310
X21 SOUT A CIN GND VDD 9 COUT 18 14 17
+ 13 15 31 34 Full_Adder $T=-3810 600 0 0 $X=-13800 $Y=-220
X22 VDD GND 11 SOUT inv $T=6090 430 0 0 $X=4850 $Y=-250
M0 11 PHI 30 GND g45n1svt w=2.4e-07 l=4.5e-08 ad=3.36e-14 as=3.36e-14 pd=7.6e-07 ps=7.6e-07 sa=1.4e-07 sb=1.4e-07 sca=3.52678 scb=0.000111658 scc=3.66286e-09 fw=2.4e-07 $X=6620 $Y=5490 $dt=0
M1 18 A VDD VDD g45p1svt w=2.4e-07 l=4.5e-08 ad=3.36e-14 as=3.36e-14 pd=7.6e-07 ps=7.6e-07 sa=1.4e-07 sb=1.4e-07 sca=13.9617 scb=0.0132915 scc=0.000629907 fw=2.4e-07 $X=-10880 $Y=2400 $dt=1
M2 17 14 VDD VDD g45p1svt w=2.4e-07 l=4.5e-08 ad=3.36e-14 as=3.36e-14 pd=7.6e-07 ps=7.6e-07 sa=1.4e-07 sb=1.4e-07 sca=13.9617 scb=0.0132915 scc=0.000629907 fw=2.4e-07 $X=-5510 $Y=2400 $dt=1
M3 17 CIN VDD VDD g45p1svt w=2.4e-07 l=4.5e-08 ad=3.36e-14 as=3.36e-14 pd=7.6e-07 ps=7.6e-07 sa=1.4e-07 sb=1.4e-07 sca=13.9617 scb=0.0132915 scc=0.000629907 fw=2.4e-07 $X=-4260 $Y=2400 $dt=1
M4 COUT 17 VDD VDD g45p1svt w=2.4e-07 l=4.5e-08 ad=3.36e-14 as=3.36e-14 pd=7.6e-07 ps=7.6e-07 sa=1.4e-07 sb=1.4e-07 sca=13.9617 scb=0.0132915 scc=0.000629907 fw=2.4e-07 $X=-2300 $Y=2400 $dt=1
M5 15 CIN VDD VDD g45p1svt w=2.4e-07 l=4.5e-08 ad=3.36e-14 as=3.36e-14 pd=7.6e-07 ps=7.6e-07 sa=1.4e-07 sb=1.4e-07 sca=34.1422 scb=0.0251568 scc=0.00441949 fw=2.4e-07 $X=-1520 $Y=9890 $dt=1
M6 COUT 18 VDD VDD g45p1svt w=2.4e-07 l=4.5e-08 ad=3.36e-14 as=3.36e-14 pd=7.6e-07 ps=7.6e-07 sa=1.4e-07 sb=1.4e-07 sca=13.9617 scb=0.0132915 scc=0.000629907 fw=2.4e-07 $X=-1050 $Y=2400 $dt=1
M7 9 14 34 VDD g45p1svt w=4.8e-07 l=4.5e-08 ad=6.72e-14 as=6.72e-14 pd=1.24e-06 ps=1.24e-06 sa=1.4e-07 sb=1.4e-07 sca=9.47395 scb=0.00759651 scc=0.000374483 fw=4.8e-07 $X=-1020 $Y=7880 $dt=1
M8 10 RST VDD VDD g45p1svt w=2.4e-07 l=4.5e-08 ad=3.36e-14 as=3.36e-14 pd=7.6e-07 ps=7.6e-07 sa=1.4e-07 sb=1.4e-07 sca=17.3073 scb=0.0169295 scc=0.00128868 fw=2.4e-07 $X=1740 $Y=2310 $dt=1
M9 19 PHI VDD VDD g45p1svt w=2.4e-07 l=4.5e-08 ad=3.36e-14 as=3.36e-14 pd=7.6e-07 ps=7.6e-07 sa=1.4e-07 sb=1.4e-07 sca=10.0441 scb=0.00891249 scc=0.000296773 fw=2.4e-07 $X=1800 $Y=8140 $dt=1
M10 10 9 VDD VDD g45p1svt w=2.4e-07 l=4.5e-08 ad=3.36e-14 as=3.36e-14 pd=7.6e-07 ps=7.6e-07 sa=1.4e-07 sb=1.4e-07 sca=17.3073 scb=0.0169295 scc=0.00128868 fw=2.4e-07 $X=2990 $Y=2310 $dt=1
M11 35 10 VDD VDD g45p1svt w=4.8e-07 l=4.5e-08 ad=6.72e-14 as=6.72e-14 pd=1.24e-06 ps=1.24e-06 sa=1.4e-07 sb=1.4e-07 sca=13.8415 scb=0.0117975 scc=0.0011174 fw=4.8e-07 $X=3040 $Y=7890 $dt=1
M12 20 PHI 35 VDD g45p1svt w=4.8e-07 l=4.5e-08 ad=6.72e-14 as=6.72e-14 pd=1.24e-06 ps=1.24e-06 sa=1.4e-07 sb=1.4e-07 sca=13.3978 scb=0.0114602 scc=0.001037 fw=4.8e-07 $X=4250 $Y=7900 $dt=1
M13 36 20 VDD VDD g45p1svt w=4.8e-07 l=4.5e-08 ad=6.72e-14 as=6.72e-14 pd=1.24e-06 ps=1.24e-06 sa=1.4e-07 sb=1.4e-07 sca=13.8415 scb=0.0117975 scc=0.0011174 fw=4.8e-07 $X=5440 $Y=7890 $dt=1
.ends faabs

* +++++++++++++++++++++++++++++++++++++++++++++++++++++++++ *
* Sub cell: Half_Adder                                      *
* +++++++++++++++++++++++++++++++++++++++++++++++++++++++++ *
.subckt Half_Adder B A GND VDD SUM COUT 7 11
*.DEVICECLIMB
** N=13 EP=8 FDC=15
X75 GND 7 A nmos1v_CDNS_10 $T=-2150 3980 0 0 $X=-2570 $Y=3780
X76 GND 8 B nmos1v_CDNS_10 $T=1510 3980 0 0 $X=1090 $Y=3780
X77 GND COUT 8 nmos1v_CDNS_10 $T=3050 3980 0 0 $X=2630 $Y=3780
X78 GND COUT 7 nmos1v_CDNS_10 $T=4390 3980 0 0 $X=3970 $Y=3780
M0 12 8 GND GND g45n1svt w=2.4e-07 l=4.5e-08 ad=3.36e-14 as=3.36e-14 pd=7.6e-07 ps=7.6e-07 sa=1.4e-07 sb=1.4e-07 sca=3.52678 scb=0.000111658 scc=3.66286e-09 fw=2.4e-07 $X=-2160 $Y=-2930 $dt=0
M1 SUM 7 12 GND g45n1svt w=2.4e-07 l=4.5e-08 ad=3.36e-14 as=3.36e-14 pd=7.6e-07 ps=7.6e-07 sa=1.4e-07 sb=1.4e-07 sca=3.52678 scb=0.000111658 scc=3.66286e-09 fw=2.4e-07 $X=-740 $Y=-2930 $dt=0
M2 13 B GND GND g45n1svt w=2.4e-07 l=4.5e-08 ad=3.36e-14 as=3.36e-14 pd=7.6e-07 ps=7.6e-07 sa=1.4e-07 sb=1.4e-07 sca=3.52678 scb=0.000111658 scc=3.66286e-09 fw=2.4e-07 $X=640 $Y=-2930 $dt=0
M3 SUM A 13 GND g45n1svt w=2.4e-07 l=4.5e-08 ad=3.36e-14 as=3.36e-14 pd=7.6e-07 ps=7.6e-07 sa=1.4e-07 sb=1.4e-07 sca=3.52678 scb=0.000111658 scc=3.66286e-09 fw=2.4e-07 $X=2010 $Y=-2930 $dt=0
M4 9 B VDD VDD g45p1svt w=4.8e-07 l=4.5e-08 ad=6.72e-14 as=6.72e-14 pd=1.24e-06 ps=1.24e-06 sa=1.4e-07 sb=1.4e-07 sca=7.67703 scb=0.00492794 scc=0.000127123 fw=4.8e-07 $X=-2160 $Y=-450 $dt=1
M5 7 A VDD VDD g45p1svt w=2.4e-07 l=4.5e-08 ad=3.36e-14 as=3.36e-14 pd=7.6e-07 ps=7.6e-07 sa=1.4e-07 sb=1.4e-07 sca=6.19868 scb=0.00224643 scc=1.06334e-05 fw=2.4e-07 $X=-2150 $Y=1560 $dt=1
M6 SUM 7 9 VDD g45p1svt w=4.8e-07 l=4.5e-08 ad=6.72e-14 as=6.72e-14 pd=1.24e-06 ps=1.24e-06 sa=1.4e-07 sb=1.4e-07 sca=7.2888 scb=0.00480939 scc=0.000127096 fw=4.8e-07 $X=-740 $Y=-450 $dt=1
M7 10 8 VDD VDD g45p1svt w=4.8e-07 l=4.5e-08 ad=6.72e-14 as=6.72e-14 pd=1.24e-06 ps=1.24e-06 sa=1.4e-07 sb=1.4e-07 sca=7.2888 scb=0.00480939 scc=0.000127096 fw=4.8e-07 $X=640 $Y=-450 $dt=1
M8 8 B VDD VDD g45p1svt w=2.4e-07 l=4.5e-08 ad=3.36e-14 as=3.36e-14 pd=7.6e-07 ps=7.6e-07 sa=1.4e-07 sb=1.4e-07 sca=5.82592 scb=0.00213462 scc=1.06087e-05 fw=2.4e-07 $X=1510 $Y=1560 $dt=1
M9 SUM A 10 VDD g45p1svt w=4.8e-07 l=4.5e-08 ad=6.72e-14 as=6.72e-14 pd=1.24e-06 ps=1.24e-06 sa=1.4e-07 sb=1.4e-07 sca=7.2888 scb=0.00480939 scc=0.000127096 fw=4.8e-07 $X=2010 $Y=-450 $dt=1
M10 11 8 VDD VDD g45p1svt w=4.8e-07 l=4.5e-08 ad=6.72e-14 as=6.72e-14 pd=1.24e-06 ps=1.24e-06 sa=1.4e-07 sb=1.4e-07 sca=7.78706 scb=0.00554847 scc=0.000178111 fw=4.8e-07 $X=3050 $Y=1480 $dt=1
.ends Half_Adder

* +++++++++++++++++++++++++++++++++++++++++++++++++++++++++ *
* Sub cell: AND                                             *
* +++++++++++++++++++++++++++++++++++++++++++++++++++++++++ *
.subckt AND VDD GND B A Y
** N=7 EP=5 FDC=6
X28 GND Y 6 nmos1v_CDNS_10 $T=420 1020 0 0 $X=0 $Y=820
M0 7 A GND GND g45n1svt w=2.4e-07 l=4.5e-08 ad=3.36e-14 as=3.36e-14 pd=7.6e-07 ps=7.6e-07 sa=1.4e-07 sb=1.4e-07 sca=3.52678 scb=0.000111658 scc=3.66286e-09 fw=2.4e-07 $X=-2110 $Y=920 $dt=0
M1 6 B 7 GND g45n1svt w=2.4e-07 l=4.5e-08 ad=3.36e-14 as=3.36e-14 pd=7.6e-07 ps=7.6e-07 sa=1.4e-07 sb=1.4e-07 sca=3.52678 scb=0.000111658 scc=3.66286e-09 fw=2.4e-07 $X=-830 $Y=920 $dt=0
M2 6 A VDD VDD g45p1svt w=2.4e-07 l=4.5e-08 ad=3.36e-14 as=3.36e-14 pd=7.6e-07 ps=7.6e-07 sa=1.4e-07 sb=1.4e-07 sca=16.0927 scb=0.0154531 scc=0.000419743 fw=2.4e-07 $X=-2110 $Y=2770 $dt=1
M3 6 B VDD VDD g45p1svt w=2.4e-07 l=4.5e-08 ad=3.36e-14 as=3.36e-14 pd=7.6e-07 ps=7.6e-07 sa=1.4e-07 sb=1.4e-07 sca=12.8329 scb=0.0117498 scc=0.000390557 fw=2.4e-07 $X=-830 $Y=2770 $dt=1
M4 Y 6 VDD VDD g45p1svt w=2.4e-07 l=4.5e-08 ad=3.36e-14 as=3.36e-14 pd=7.6e-07 ps=7.6e-07 sa=1.4e-07 sb=1.4e-07 sca=15.9246 scb=0.0151668 scc=0.000414946 fw=2.4e-07 $X=420 $Y=2770 $dt=1
.ends AND

* +++++++++++++++++++++++++++++++++++++++++++++++++++++++++ *
* Sub cell: Multiplier_ppl                                  *
* +++++++++++++++++++++++++++++++++++++++++++++++++++++++++ *
.subckt Multiplier_ppl VDD PHI A0 A1 A2 A3 B0 B3 B1 B2
+ GND P3 P4 P5 P2 P7 P6 P1 P0
** N=381 EP=19 FDC=632
X389 VDD GND B3 PHI 29 79 80 305 306 187 FlipFlop $T=-24980 -21210 0 0 $X=-28390 $Y=-21610
X390 VDD GND 27 PHI 31 83 84 315 316 198 FlipFlop $T=-22810 2120 0 0 $X=-26220 $Y=1720
X391 VDD GND 24 PHI 37 81 82 313 314 196 FlipFlop $T=-22740 -13470 0 0 $X=-26150 $Y=-13870
X392 VDD GND A0 PHI 28 86 87 317 318 201 FlipFlop $T=-17920 -21210 0 0 $X=-21330 $Y=-21610
X393 VDD GND 32 PHI 41 111 112 331 332 226 FlipFlop $T=-15910 2120 0 0 $X=-19320 $Y=1720
X394 VDD GND A1 PHI 43 116 117 333 334 232 FlipFlop $T=-10850 -21210 0 0 $X=-14260 $Y=-21610
X395 VDD GND 44 PHI 45 114 115 335 336 230 FlipFlop $T=-8370 2110 0 0 $X=-11780 $Y=1710
X396 VDD GND A2 PHI 55 120 121 337 338 234 FlipFlop $T=-3790 -21210 0 0 $X=-7200 $Y=-21610
X397 VDD GND 46 PHI 53 118 119 351 352 236 FlipFlop $T=-840 2110 0 0 $X=-4250 $Y=1710
X398 VDD GND A3 PHI 56 147 148 353 354 262 FlipFlop $T=3270 -21210 0 0 $X=-140 $Y=-21610
X399 VDD GND A3 PHI 57 145 146 355 356 265 FlipFlop $T=6700 2110 0 0 $X=3290 $Y=1710
X400 VDD GND B2 PHI 61 150 151 369 370 291 FlipFlop $T=14230 7820 0 0 $X=10820 $Y=7420
X401 VDD GND 34 PHI P2 175 176 374 375 295 FlipFlop $T=17880 -21210 0 0 $X=14470 $Y=-21610
X402 VDD GND 30 PHI P0 181 182 376 377 301 FlipFlop $T=20460 34180 0 0 $X=17050 $Y=33780
X403 VDD GND 68 PHI 65 179 180 380 381 299 FlipFlop $T=21760 1690 0 0 $X=18350 $Y=1290
X404 VDD GND 33 PHI P1 177 178 378 379 297 FlipFlop $T=21760 7820 0 0 $X=18350 $Y=7420
X405 VDD GND 20 28 29 NAND $T=-23460 -29960 0 0 $X=-25780 $Y=-31200
X406 VDD GND 38 43 29 NAND $T=-14180 -29960 0 0 $X=-16500 $Y=-31200
X407 VDD GND 50 55 29 NAND $T=720 -29960 0 0 $X=-1600 $Y=-31200
X408 VDD GND 54 A3 B0 NAND $T=6870 38680 0 0 $X=4550 $Y=37440
X409 VDD GND 66 A3 B1 NAND $T=10150 32510 0 0 $X=7830 $Y=31270
X410 VDD GND 63 57 61 NAND $T=13310 2990 0 0 $X=10990 $Y=1750
X411 38 40 35 GND VDD P4 47 110 106 109
+ 105 107 327 330 Full_Adder $T=-7710 -44360 0 0 $X=-17700 $Y=-45180
X412 31 41 37 GND VDD 21 48 103 99 102
+ 98 100 323 326 Full_Adder $T=-7710 -11450 0 0 $X=-17700 $Y=-12270
X413 39 42 36 GND VDD 25 49 96 92 95
+ 91 93 319 322 Full_Adder $T=-7710 17810 0 0 $X=-17700 $Y=16990
X414 50 52 47 GND VDD P5 58 144 140 143
+ 139 141 347 350 Full_Adder $T=7200 -44360 0 0 $X=-2790 $Y=-45180
X415 45 53 48 GND VDD 40 59 137 133 136
+ 132 134 343 346 Full_Adder $T=7200 -11450 0 0 $X=-2790 $Y=-12270
X416 51 54 49 GND VDD 32 60 130 126 129
+ 125 127 339 342 Full_Adder $T=7200 17810 0 0 $X=-2790 $Y=16990
X417 62 64 58 GND VDD P6 67 174 170 173
+ 169 171 365 368 Full_Adder $T=21450 -44330 0 0 $X=11460 $Y=-45150
X418 63 65 59 GND VDD 52 64 167 163 166
+ 162 164 361 364 Full_Adder $T=21450 -11420 0 0 $X=11460 $Y=-12240
X419 VDD 66 60 GND VDD 46 68 160 156 159
+ 155 157 357 360 Full_Adder $T=21450 17840 0 0 $X=11460 $Y=17020
X420 20 21 GND VDD P3 35 78 304 Half_Adder $T=-24870 -37710 0 0 $X=-28710 $Y=-41460
X421 22 25 GND VDD 34 24 76 312 Half_Adder $T=-23440 -4410 0 0 $X=-27280 $Y=-8160
X422 23 26 GND VDD 33 36 74 309 Half_Adder $T=-23440 24830 0 0 $X=-27280 $Y=21080
X423 VDD 67 GND VDD P7 69 153 373 Half_Adder $T=18230 -27610 0 0 $X=14390 $Y=-31360
X424 VDD GND A0 B0 30 AND $T=-25830 37300 0 0 $X=-28870 $Y=37450
X425 VDD GND A0 B2 22 AND $T=-24080 9360 0 0 $X=-27120 $Y=9510
X426 VDD GND A0 B1 23 AND $T=-24080 31190 0 0 $X=-27120 $Y=31340
X427 VDD GND A1 B0 26 AND $T=-18900 37300 0 0 $X=-21940 $Y=37450
X428 VDD GND A1 B2 27 AND $T=-14240 9360 0 0 $X=-17280 $Y=9510
X429 VDD GND A1 B1 39 AND $T=-14240 31190 0 0 $X=-17280 $Y=31340
X430 VDD GND A2 B0 42 AND $T=-9060 37300 0 0 $X=-12100 $Y=37450
X431 VDD GND A2 B2 44 AND $T=690 9360 0 0 $X=-2350 $Y=9510
X432 VDD GND A2 B1 51 AND $T=690 31190 0 0 $X=-2350 $Y=31340
X433 VDD GND 56 29 62 AND $T=7990 -31350 0 0 $X=4950 $Y=-31200
M0 29 PHI 187 GND g45n1svt w=2.4e-07 l=4.5e-08 ad=3.36e-14 as=3.36e-14 pd=7.6e-07 ps=7.6e-07 sa=1.4e-07 sb=1.4e-07 sca=3.52678 scb=0.000111658 scc=3.66286e-09 fw=2.4e-07 $X=-22660 $Y=-20700 $dt=0
M1 31 PHI 198 GND g45n1svt w=2.4e-07 l=4.5e-08 ad=3.36e-14 as=3.36e-14 pd=7.6e-07 ps=7.6e-07 sa=1.4e-07 sb=1.4e-07 sca=3.52678 scb=0.000111658 scc=3.66286e-09 fw=2.4e-07 $X=-20490 $Y=2630 $dt=0
M2 37 PHI 196 GND g45n1svt w=2.4e-07 l=4.5e-08 ad=3.36e-14 as=3.36e-14 pd=7.6e-07 ps=7.6e-07 sa=1.4e-07 sb=1.4e-07 sca=3.52678 scb=0.000111658 scc=3.66286e-09 fw=2.4e-07 $X=-20420 $Y=-12960 $dt=0
M3 28 PHI 201 GND g45n1svt w=2.4e-07 l=4.5e-08 ad=3.36e-14 as=3.36e-14 pd=7.6e-07 ps=7.6e-07 sa=1.4e-07 sb=1.4e-07 sca=3.52678 scb=0.000111658 scc=3.66286e-09 fw=2.4e-07 $X=-15600 $Y=-20700 $dt=0
M4 41 PHI 226 GND g45n1svt w=2.4e-07 l=4.5e-08 ad=3.36e-14 as=3.36e-14 pd=7.6e-07 ps=7.6e-07 sa=1.4e-07 sb=1.4e-07 sca=3.52678 scb=0.000111658 scc=3.66286e-09 fw=2.4e-07 $X=-13590 $Y=2630 $dt=0
M5 43 PHI 232 GND g45n1svt w=2.4e-07 l=4.5e-08 ad=3.36e-14 as=3.36e-14 pd=7.6e-07 ps=7.6e-07 sa=1.4e-07 sb=1.4e-07 sca=3.52678 scb=0.000111658 scc=3.66286e-09 fw=2.4e-07 $X=-8530 $Y=-20700 $dt=0
M6 45 PHI 230 GND g45n1svt w=2.4e-07 l=4.5e-08 ad=3.36e-14 as=3.36e-14 pd=7.6e-07 ps=7.6e-07 sa=1.4e-07 sb=1.4e-07 sca=3.52678 scb=0.000111658 scc=3.66286e-09 fw=2.4e-07 $X=-6050 $Y=2620 $dt=0
M7 55 PHI 234 GND g45n1svt w=2.4e-07 l=4.5e-08 ad=3.36e-14 as=3.36e-14 pd=7.6e-07 ps=7.6e-07 sa=1.4e-07 sb=1.4e-07 sca=3.52678 scb=0.000111658 scc=3.66286e-09 fw=2.4e-07 $X=-1470 $Y=-20700 $dt=0
M8 53 PHI 236 GND g45n1svt w=2.4e-07 l=4.5e-08 ad=3.36e-14 as=3.36e-14 pd=7.6e-07 ps=7.6e-07 sa=1.4e-07 sb=1.4e-07 sca=3.52678 scb=0.000111658 scc=3.66286e-09 fw=2.4e-07 $X=1480 $Y=2620 $dt=0
M9 56 PHI 262 GND g45n1svt w=2.4e-07 l=4.5e-08 ad=3.36e-14 as=3.36e-14 pd=7.6e-07 ps=7.6e-07 sa=1.4e-07 sb=1.4e-07 sca=3.52678 scb=0.000111658 scc=3.66286e-09 fw=2.4e-07 $X=5590 $Y=-20700 $dt=0
M10 57 PHI 265 GND g45n1svt w=2.4e-07 l=4.5e-08 ad=3.36e-14 as=3.36e-14 pd=7.6e-07 ps=7.6e-07 sa=1.4e-07 sb=1.4e-07 sca=3.52678 scb=0.000111658 scc=3.66286e-09 fw=2.4e-07 $X=9020 $Y=2620 $dt=0
M11 61 PHI 291 GND g45n1svt w=2.4e-07 l=4.5e-08 ad=3.36e-14 as=3.36e-14 pd=7.6e-07 ps=7.6e-07 sa=1.4e-07 sb=1.4e-07 sca=3.52678 scb=0.000111658 scc=3.66286e-09 fw=2.4e-07 $X=16550 $Y=8330 $dt=0
M12 P2 PHI 295 GND g45n1svt w=2.4e-07 l=4.5e-08 ad=3.36e-14 as=3.36e-14 pd=7.6e-07 ps=7.6e-07 sa=1.4e-07 sb=1.4e-07 sca=3.52678 scb=0.000111658 scc=3.66286e-09 fw=2.4e-07 $X=20200 $Y=-20700 $dt=0
M13 P0 PHI 301 GND g45n1svt w=2.4e-07 l=4.5e-08 ad=3.36e-14 as=3.36e-14 pd=7.6e-07 ps=7.6e-07 sa=1.4e-07 sb=1.4e-07 sca=3.52678 scb=0.000111658 scc=3.66286e-09 fw=2.4e-07 $X=22780 $Y=34690 $dt=0
M14 65 PHI 299 GND g45n1svt w=2.4e-07 l=4.5e-08 ad=3.36e-14 as=3.36e-14 pd=7.6e-07 ps=7.6e-07 sa=1.4e-07 sb=1.4e-07 sca=3.52678 scb=0.000111658 scc=3.66286e-09 fw=2.4e-07 $X=24080 $Y=2200 $dt=0
M15 P1 PHI 297 GND g45n1svt w=2.4e-07 l=4.5e-08 ad=3.36e-14 as=3.36e-14 pd=7.6e-07 ps=7.6e-07 sa=1.4e-07 sb=1.4e-07 sca=3.52678 scb=0.000111658 scc=3.66286e-09 fw=2.4e-07 $X=24080 $Y=8330 $dt=0
M16 79 PHI VDD VDD g45p1svt w=2.4e-07 l=4.5e-08 ad=3.36e-14 as=3.36e-14 pd=7.6e-07 ps=7.6e-07 sa=1.4e-07 sb=1.4e-07 sca=15.0576 scb=0.0142053 scc=0.000386892 fw=2.4e-07 $X=-27480 $Y=-18050 $dt=1
M17 305 B3 VDD VDD g45p1svt w=4.8e-07 l=4.5e-08 ad=6.72e-14 as=6.72e-14 pd=1.24e-06 ps=1.24e-06 sa=1.4e-07 sb=1.4e-07 sca=16.1286 scb=0.0134283 scc=0.00129853 fw=4.8e-07 $X=-26240 $Y=-18300 $dt=1
M18 83 PHI VDD VDD g45p1svt w=2.4e-07 l=4.5e-08 ad=3.36e-14 as=3.36e-14 pd=7.6e-07 ps=7.6e-07 sa=1.4e-07 sb=1.4e-07 sca=15.0576 scb=0.0142053 scc=0.000386892 fw=2.4e-07 $X=-25310 $Y=5280 $dt=1
M19 81 PHI VDD VDD g45p1svt w=2.4e-07 l=4.5e-08 ad=3.36e-14 as=3.36e-14 pd=7.6e-07 ps=7.6e-07 sa=1.4e-07 sb=1.4e-07 sca=15.0576 scb=0.0142053 scc=0.000386892 fw=2.4e-07 $X=-25240 $Y=-10310 $dt=1
M20 20 29 VDD VDD g45p1svt w=2.4e-07 l=4.5e-08 ad=3.36e-14 as=3.36e-14 pd=7.6e-07 ps=7.6e-07 sa=1.4e-07 sb=1.4e-07 sca=27.6029 scb=0.0286946 scc=0.00220115 fw=2.4e-07 $X=-25040 $Y=-28580 $dt=1
M21 80 PHI 305 VDD g45p1svt w=4.8e-07 l=4.5e-08 ad=6.72e-14 as=6.72e-14 pd=1.24e-06 ps=1.24e-06 sa=1.4e-07 sb=1.4e-07 sca=15.6391 scb=0.0131208 scc=0.00120734 fw=4.8e-07 $X=-25030 $Y=-18290 $dt=1
M22 315 27 VDD VDD g45p1svt w=4.8e-07 l=4.5e-08 ad=6.72e-14 as=6.72e-14 pd=1.24e-06 ps=1.24e-06 sa=1.4e-07 sb=1.4e-07 sca=16.1286 scb=0.0134283 scc=0.00129853 fw=4.8e-07 $X=-24070 $Y=5030 $dt=1
M23 313 24 VDD VDD g45p1svt w=4.8e-07 l=4.5e-08 ad=6.72e-14 as=6.72e-14 pd=1.24e-06 ps=1.24e-06 sa=1.4e-07 sb=1.4e-07 sca=16.1286 scb=0.0134283 scc=0.00129853 fw=4.8e-07 $X=-24000 $Y=-10560 $dt=1
M24 306 80 VDD VDD g45p1svt w=4.8e-07 l=4.5e-08 ad=6.72e-14 as=6.72e-14 pd=1.24e-06 ps=1.24e-06 sa=1.4e-07 sb=1.4e-07 sca=16.1286 scb=0.0134283 scc=0.00129853 fw=4.8e-07 $X=-23840 $Y=-18300 $dt=1
M25 20 28 VDD VDD g45p1svt w=2.4e-07 l=4.5e-08 ad=3.36e-14 as=3.36e-14 pd=7.6e-07 ps=7.6e-07 sa=1.4e-07 sb=1.4e-07 sca=30.3216 scb=0.0333085 scc=0.0025237 fw=2.4e-07 $X=-23790 $Y=-28580 $dt=1
M26 84 PHI 315 VDD g45p1svt w=4.8e-07 l=4.5e-08 ad=6.72e-14 as=6.72e-14 pd=1.24e-06 ps=1.24e-06 sa=1.4e-07 sb=1.4e-07 sca=15.6391 scb=0.0131208 scc=0.00120734 fw=4.8e-07 $X=-22860 $Y=5040 $dt=1
M27 82 PHI 313 VDD g45p1svt w=4.8e-07 l=4.5e-08 ad=6.72e-14 as=6.72e-14 pd=1.24e-06 ps=1.24e-06 sa=1.4e-07 sb=1.4e-07 sca=15.6391 scb=0.0131208 scc=0.00120734 fw=4.8e-07 $X=-22790 $Y=-10550 $dt=1
M28 29 79 306 VDD g45p1svt w=4.8e-07 l=4.5e-08 ad=6.72e-14 as=6.72e-14 pd=1.24e-06 ps=1.24e-06 sa=1.4e-07 sb=1.4e-07 sca=15.6391 scb=0.0131208 scc=0.00120734 fw=4.8e-07 $X=-22660 $Y=-18290 $dt=1
M29 316 84 VDD VDD g45p1svt w=4.8e-07 l=4.5e-08 ad=6.72e-14 as=6.72e-14 pd=1.24e-06 ps=1.24e-06 sa=1.4e-07 sb=1.4e-07 sca=16.1286 scb=0.0134283 scc=0.00129853 fw=4.8e-07 $X=-21670 $Y=5030 $dt=1
M30 314 82 VDD VDD g45p1svt w=4.8e-07 l=4.5e-08 ad=6.72e-14 as=6.72e-14 pd=1.24e-06 ps=1.24e-06 sa=1.4e-07 sb=1.4e-07 sca=16.1286 scb=0.0134283 scc=0.00129853 fw=4.8e-07 $X=-21600 $Y=-10560 $dt=1
M31 31 83 316 VDD g45p1svt w=4.8e-07 l=4.5e-08 ad=6.72e-14 as=6.72e-14 pd=1.24e-06 ps=1.24e-06 sa=1.4e-07 sb=1.4e-07 sca=15.6391 scb=0.0131208 scc=0.00120734 fw=4.8e-07 $X=-20490 $Y=5040 $dt=1
M32 35 78 304 VDD g45p1svt w=4.8e-07 l=4.5e-08 ad=6.72e-14 as=6.72e-14 pd=1.24e-06 ps=1.24e-06 sa=1.4e-07 sb=1.4e-07 sca=7.78706 scb=0.00554847 scc=0.000178111 fw=4.8e-07 $X=-20480 $Y=-36230 $dt=1
M33 86 PHI VDD VDD g45p1svt w=2.4e-07 l=4.5e-08 ad=3.36e-14 as=3.36e-14 pd=7.6e-07 ps=7.6e-07 sa=1.4e-07 sb=1.4e-07 sca=11.619 scb=0.0101937 scc=0.000351981 fw=2.4e-07 $X=-20420 $Y=-18050 $dt=1
M34 37 81 314 VDD g45p1svt w=4.8e-07 l=4.5e-08 ad=6.72e-14 as=6.72e-14 pd=1.24e-06 ps=1.24e-06 sa=1.4e-07 sb=1.4e-07 sca=18.4233 scb=0.0160258 scc=0.00122435 fw=4.8e-07 $X=-20420 $Y=-10550 $dt=1
M35 317 A0 VDD VDD g45p1svt w=4.8e-07 l=4.5e-08 ad=6.72e-14 as=6.72e-14 pd=1.24e-06 ps=1.24e-06 sa=1.4e-07 sb=1.4e-07 sca=16.1286 scb=0.0134283 scc=0.00129853 fw=4.8e-07 $X=-19180 $Y=-18300 $dt=1
M36 24 76 312 VDD g45p1svt w=4.8e-07 l=4.5e-08 ad=6.72e-14 as=6.72e-14 pd=1.24e-06 ps=1.24e-06 sa=1.4e-07 sb=1.4e-07 sca=7.78706 scb=0.00554847 scc=0.000178111 fw=4.8e-07 $X=-19050 $Y=-2930 $dt=1
M37 36 74 309 VDD g45p1svt w=4.8e-07 l=4.5e-08 ad=6.72e-14 as=6.72e-14 pd=1.24e-06 ps=1.24e-06 sa=1.4e-07 sb=1.4e-07 sca=7.78706 scb=0.00554847 scc=0.000178111 fw=4.8e-07 $X=-19050 $Y=26310 $dt=1
M38 111 PHI VDD VDD g45p1svt w=2.4e-07 l=4.5e-08 ad=3.36e-14 as=3.36e-14 pd=7.6e-07 ps=7.6e-07 sa=1.4e-07 sb=1.4e-07 sca=11.619 scb=0.0101937 scc=0.000351981 fw=2.4e-07 $X=-18410 $Y=5280 $dt=1
M39 87 PHI 317 VDD g45p1svt w=4.8e-07 l=4.5e-08 ad=6.72e-14 as=6.72e-14 pd=1.24e-06 ps=1.24e-06 sa=1.4e-07 sb=1.4e-07 sca=15.6391 scb=0.0131208 scc=0.00120734 fw=4.8e-07 $X=-17970 $Y=-18290 $dt=1
M40 331 32 VDD VDD g45p1svt w=4.8e-07 l=4.5e-08 ad=6.72e-14 as=6.72e-14 pd=1.24e-06 ps=1.24e-06 sa=1.4e-07 sb=1.4e-07 sca=16.1286 scb=0.0134283 scc=0.00129853 fw=4.8e-07 $X=-17170 $Y=5030 $dt=1
M41 318 87 VDD VDD g45p1svt w=4.8e-07 l=4.5e-08 ad=6.72e-14 as=6.72e-14 pd=1.24e-06 ps=1.24e-06 sa=1.4e-07 sb=1.4e-07 sca=16.1286 scb=0.0134283 scc=0.00129853 fw=4.8e-07 $X=-16780 $Y=-18300 $dt=1
M42 110 38 VDD VDD g45p1svt w=2.4e-07 l=4.5e-08 ad=3.36e-14 as=3.36e-14 pd=7.6e-07 ps=7.6e-07 sa=1.4e-07 sb=1.4e-07 sca=22.1446 scb=0.0211749 scc=0.0017623 fw=2.4e-07 $X=-16030 $Y=-42560 $dt=1
M43 103 31 VDD VDD g45p1svt w=2.4e-07 l=4.5e-08 ad=3.36e-14 as=3.36e-14 pd=7.6e-07 ps=7.6e-07 sa=1.4e-07 sb=1.4e-07 sca=22.1446 scb=0.0211749 scc=0.0017623 fw=2.4e-07 $X=-16030 $Y=-9650 $dt=1
M44 96 39 VDD VDD g45p1svt w=2.4e-07 l=4.5e-08 ad=3.36e-14 as=3.36e-14 pd=7.6e-07 ps=7.6e-07 sa=1.4e-07 sb=1.4e-07 sca=22.1446 scb=0.0211749 scc=0.0017623 fw=2.4e-07 $X=-16030 $Y=19610 $dt=1
M45 112 PHI 331 VDD g45p1svt w=4.8e-07 l=4.5e-08 ad=6.72e-14 as=6.72e-14 pd=1.24e-06 ps=1.24e-06 sa=1.4e-07 sb=1.4e-07 sca=15.6391 scb=0.0131208 scc=0.00120734 fw=4.8e-07 $X=-15960 $Y=5040 $dt=1
M46 327 38 VDD VDD g45p1svt w=4.8e-07 l=4.5e-08 ad=6.72e-14 as=6.72e-14 pd=1.24e-06 ps=1.24e-06 sa=1.4e-07 sb=1.4e-07 sca=9.47395 scb=0.00759651 scc=0.000374483 fw=4.8e-07 $X=-15900 $Y=-37080 $dt=1
M47 323 31 VDD VDD g45p1svt w=4.8e-07 l=4.5e-08 ad=6.72e-14 as=6.72e-14 pd=1.24e-06 ps=1.24e-06 sa=1.4e-07 sb=1.4e-07 sca=9.47395 scb=0.00759651 scc=0.000374483 fw=4.8e-07 $X=-15900 $Y=-4170 $dt=1
M48 319 39 VDD VDD g45p1svt w=4.8e-07 l=4.5e-08 ad=6.72e-14 as=6.72e-14 pd=1.24e-06 ps=1.24e-06 sa=1.4e-07 sb=1.4e-07 sca=9.47395 scb=0.00759651 scc=0.000374483 fw=4.8e-07 $X=-15900 $Y=25090 $dt=1
M49 105 40 VDD VDD g45p1svt w=2.4e-07 l=4.5e-08 ad=3.36e-14 as=3.36e-14 pd=7.6e-07 ps=7.6e-07 sa=1.4e-07 sb=1.4e-07 sca=34.1422 scb=0.0251568 scc=0.00441949 fw=2.4e-07 $X=-15890 $Y=-35070 $dt=1
M50 98 41 VDD VDD g45p1svt w=2.4e-07 l=4.5e-08 ad=3.36e-14 as=3.36e-14 pd=7.6e-07 ps=7.6e-07 sa=1.4e-07 sb=1.4e-07 sca=34.1422 scb=0.0251568 scc=0.00441949 fw=2.4e-07 $X=-15890 $Y=-2160 $dt=1
M51 91 42 VDD VDD g45p1svt w=2.4e-07 l=4.5e-08 ad=3.36e-14 as=3.36e-14 pd=7.6e-07 ps=7.6e-07 sa=1.4e-07 sb=1.4e-07 sca=34.1422 scb=0.0251568 scc=0.00441949 fw=2.4e-07 $X=-15890 $Y=27100 $dt=1
M52 38 29 VDD VDD g45p1svt w=2.4e-07 l=4.5e-08 ad=3.36e-14 as=3.36e-14 pd=7.6e-07 ps=7.6e-07 sa=1.4e-07 sb=1.4e-07 sca=27.6029 scb=0.0286946 scc=0.00220115 fw=2.4e-07 $X=-15760 $Y=-28580 $dt=1
M53 28 86 318 VDD g45p1svt w=4.8e-07 l=4.5e-08 ad=6.72e-14 as=6.72e-14 pd=1.24e-06 ps=1.24e-06 sa=1.4e-07 sb=1.4e-07 sca=15.6391 scb=0.0131208 scc=0.00120734 fw=4.8e-07 $X=-15600 $Y=-18290 $dt=1
M54 110 40 VDD VDD g45p1svt w=2.4e-07 l=4.5e-08 ad=3.36e-14 as=3.36e-14 pd=7.6e-07 ps=7.6e-07 sa=1.4e-07 sb=1.4e-07 sca=20.4324 scb=0.0198648 scc=0.00175929 fw=2.4e-07 $X=-14780 $Y=-42560 $dt=1
M55 103 41 VDD VDD g45p1svt w=2.4e-07 l=4.5e-08 ad=3.36e-14 as=3.36e-14 pd=7.6e-07 ps=7.6e-07 sa=1.4e-07 sb=1.4e-07 sca=20.4324 scb=0.0198648 scc=0.00175929 fw=2.4e-07 $X=-14780 $Y=-9650 $dt=1
M56 96 42 VDD VDD g45p1svt w=2.4e-07 l=4.5e-08 ad=3.36e-14 as=3.36e-14 pd=7.6e-07 ps=7.6e-07 sa=1.4e-07 sb=1.4e-07 sca=20.4324 scb=0.0198648 scc=0.00175929 fw=2.4e-07 $X=-14780 $Y=19610 $dt=1
M57 332 112 VDD VDD g45p1svt w=4.8e-07 l=4.5e-08 ad=6.72e-14 as=6.72e-14 pd=1.24e-06 ps=1.24e-06 sa=1.4e-07 sb=1.4e-07 sca=16.1286 scb=0.0134283 scc=0.00129853 fw=4.8e-07 $X=-14770 $Y=5030 $dt=1
M58 38 43 VDD VDD g45p1svt w=2.4e-07 l=4.5e-08 ad=3.36e-14 as=3.36e-14 pd=7.6e-07 ps=7.6e-07 sa=1.4e-07 sb=1.4e-07 sca=30.3216 scb=0.0333085 scc=0.0025237 fw=2.4e-07 $X=-14510 $Y=-28580 $dt=1
M59 41 111 332 VDD g45p1svt w=4.8e-07 l=4.5e-08 ad=6.72e-14 as=6.72e-14 pd=1.24e-06 ps=1.24e-06 sa=1.4e-07 sb=1.4e-07 sca=15.6391 scb=0.0131208 scc=0.00120734 fw=4.8e-07 $X=-13590 $Y=5040 $dt=1
M60 116 PHI VDD VDD g45p1svt w=2.4e-07 l=4.5e-08 ad=3.36e-14 as=3.36e-14 pd=7.6e-07 ps=7.6e-07 sa=1.4e-07 sb=1.4e-07 sca=11.619 scb=0.0101937 scc=0.000351981 fw=2.4e-07 $X=-13350 $Y=-18050 $dt=1
M61 333 A1 VDD VDD g45p1svt w=4.8e-07 l=4.5e-08 ad=6.72e-14 as=6.72e-14 pd=1.24e-06 ps=1.24e-06 sa=1.4e-07 sb=1.4e-07 sca=16.1286 scb=0.0134283 scc=0.00129853 fw=4.8e-07 $X=-12110 $Y=-18300 $dt=1
M62 117 PHI 333 VDD g45p1svt w=4.8e-07 l=4.5e-08 ad=6.72e-14 as=6.72e-14 pd=1.24e-06 ps=1.24e-06 sa=1.4e-07 sb=1.4e-07 sca=15.6391 scb=0.0131208 scc=0.00120734 fw=4.8e-07 $X=-10900 $Y=-18290 $dt=1
M63 114 PHI VDD VDD g45p1svt w=2.4e-07 l=4.5e-08 ad=3.36e-14 as=3.36e-14 pd=7.6e-07 ps=7.6e-07 sa=1.4e-07 sb=1.4e-07 sca=11.619 scb=0.0101937 scc=0.000351981 fw=2.4e-07 $X=-10870 $Y=5270 $dt=1
M64 334 117 VDD VDD g45p1svt w=4.8e-07 l=4.5e-08 ad=6.72e-14 as=6.72e-14 pd=1.24e-06 ps=1.24e-06 sa=1.4e-07 sb=1.4e-07 sca=16.1286 scb=0.0134283 scc=0.00129853 fw=4.8e-07 $X=-9710 $Y=-18300 $dt=1
M65 335 44 VDD VDD g45p1svt w=4.8e-07 l=4.5e-08 ad=6.72e-14 as=6.72e-14 pd=1.24e-06 ps=1.24e-06 sa=1.4e-07 sb=1.4e-07 sca=16.1286 scb=0.0134283 scc=0.00129853 fw=4.8e-07 $X=-9630 $Y=5020 $dt=1
M66 109 106 VDD VDD g45p1svt w=2.4e-07 l=4.5e-08 ad=3.36e-14 as=3.36e-14 pd=7.6e-07 ps=7.6e-07 sa=1.4e-07 sb=1.4e-07 sca=20.4324 scb=0.0198648 scc=0.00175929 fw=2.4e-07 $X=-9410 $Y=-42560 $dt=1
M67 102 99 VDD VDD g45p1svt w=2.4e-07 l=4.5e-08 ad=3.36e-14 as=3.36e-14 pd=7.6e-07 ps=7.6e-07 sa=1.4e-07 sb=1.4e-07 sca=20.4324 scb=0.0198648 scc=0.00175929 fw=2.4e-07 $X=-9410 $Y=-9650 $dt=1
M68 95 92 VDD VDD g45p1svt w=2.4e-07 l=4.5e-08 ad=3.36e-14 as=3.36e-14 pd=7.6e-07 ps=7.6e-07 sa=1.4e-07 sb=1.4e-07 sca=20.4324 scb=0.0198648 scc=0.00175929 fw=2.4e-07 $X=-9410 $Y=19610 $dt=1
M69 43 116 334 VDD g45p1svt w=4.8e-07 l=4.5e-08 ad=6.72e-14 as=6.72e-14 pd=1.24e-06 ps=1.24e-06 sa=1.4e-07 sb=1.4e-07 sca=15.6391 scb=0.0131208 scc=0.00120734 fw=4.8e-07 $X=-8530 $Y=-18290 $dt=1
M70 115 PHI 335 VDD g45p1svt w=4.8e-07 l=4.5e-08 ad=6.72e-14 as=6.72e-14 pd=1.24e-06 ps=1.24e-06 sa=1.4e-07 sb=1.4e-07 sca=15.6391 scb=0.0131208 scc=0.00120734 fw=4.8e-07 $X=-8420 $Y=5030 $dt=1
M71 109 35 VDD VDD g45p1svt w=2.4e-07 l=4.5e-08 ad=3.36e-14 as=3.36e-14 pd=7.6e-07 ps=7.6e-07 sa=1.4e-07 sb=1.4e-07 sca=20.4324 scb=0.0198648 scc=0.00175929 fw=2.4e-07 $X=-8160 $Y=-42560 $dt=1
M72 102 37 VDD VDD g45p1svt w=2.4e-07 l=4.5e-08 ad=3.36e-14 as=3.36e-14 pd=7.6e-07 ps=7.6e-07 sa=1.4e-07 sb=1.4e-07 sca=20.4324 scb=0.0198648 scc=0.00175929 fw=2.4e-07 $X=-8160 $Y=-9650 $dt=1
M73 95 36 VDD VDD g45p1svt w=2.4e-07 l=4.5e-08 ad=3.36e-14 as=3.36e-14 pd=7.6e-07 ps=7.6e-07 sa=1.4e-07 sb=1.4e-07 sca=20.4324 scb=0.0198648 scc=0.00175929 fw=2.4e-07 $X=-8160 $Y=19610 $dt=1
M74 336 115 VDD VDD g45p1svt w=4.8e-07 l=4.5e-08 ad=6.72e-14 as=6.72e-14 pd=1.24e-06 ps=1.24e-06 sa=1.4e-07 sb=1.4e-07 sca=16.1286 scb=0.0134283 scc=0.00129853 fw=4.8e-07 $X=-7230 $Y=5020 $dt=1
M75 120 PHI VDD VDD g45p1svt w=2.4e-07 l=4.5e-08 ad=3.36e-14 as=3.36e-14 pd=7.6e-07 ps=7.6e-07 sa=1.4e-07 sb=1.4e-07 sca=11.619 scb=0.0101937 scc=0.000351981 fw=2.4e-07 $X=-6290 $Y=-18050 $dt=1
M76 47 109 VDD VDD g45p1svt w=2.4e-07 l=4.5e-08 ad=3.36e-14 as=3.36e-14 pd=7.6e-07 ps=7.6e-07 sa=1.4e-07 sb=1.4e-07 sca=20.4324 scb=0.0198648 scc=0.00175929 fw=2.4e-07 $X=-6200 $Y=-42560 $dt=1
M77 48 102 VDD VDD g45p1svt w=2.4e-07 l=4.5e-08 ad=3.36e-14 as=3.36e-14 pd=7.6e-07 ps=7.6e-07 sa=1.4e-07 sb=1.4e-07 sca=20.4324 scb=0.0198648 scc=0.00175929 fw=2.4e-07 $X=-6200 $Y=-9650 $dt=1
M78 49 95 VDD VDD g45p1svt w=2.4e-07 l=4.5e-08 ad=3.36e-14 as=3.36e-14 pd=7.6e-07 ps=7.6e-07 sa=1.4e-07 sb=1.4e-07 sca=20.4324 scb=0.0198648 scc=0.00175929 fw=2.4e-07 $X=-6200 $Y=19610 $dt=1
M79 45 114 336 VDD g45p1svt w=4.8e-07 l=4.5e-08 ad=6.72e-14 as=6.72e-14 pd=1.24e-06 ps=1.24e-06 sa=1.4e-07 sb=1.4e-07 sca=15.6391 scb=0.0131208 scc=0.00120734 fw=4.8e-07 $X=-6050 $Y=5030 $dt=1
M80 107 35 VDD VDD g45p1svt w=2.4e-07 l=4.5e-08 ad=3.36e-14 as=3.36e-14 pd=7.6e-07 ps=7.6e-07 sa=1.4e-07 sb=1.4e-07 sca=34.1422 scb=0.0251568 scc=0.00441949 fw=2.4e-07 $X=-5420 $Y=-35070 $dt=1
M81 100 37 VDD VDD g45p1svt w=2.4e-07 l=4.5e-08 ad=3.36e-14 as=3.36e-14 pd=7.6e-07 ps=7.6e-07 sa=1.4e-07 sb=1.4e-07 sca=34.1422 scb=0.0251568 scc=0.00441949 fw=2.4e-07 $X=-5420 $Y=-2160 $dt=1
M82 93 36 VDD VDD g45p1svt w=2.4e-07 l=4.5e-08 ad=3.36e-14 as=3.36e-14 pd=7.6e-07 ps=7.6e-07 sa=1.4e-07 sb=1.4e-07 sca=34.1422 scb=0.0251568 scc=0.00441949 fw=2.4e-07 $X=-5420 $Y=27100 $dt=1
M83 337 A2 VDD VDD g45p1svt w=4.8e-07 l=4.5e-08 ad=6.72e-14 as=6.72e-14 pd=1.24e-06 ps=1.24e-06 sa=1.4e-07 sb=1.4e-07 sca=16.1286 scb=0.0134283 scc=0.00129853 fw=4.8e-07 $X=-5050 $Y=-18300 $dt=1
M84 47 110 VDD VDD g45p1svt w=2.4e-07 l=4.5e-08 ad=3.36e-14 as=3.36e-14 pd=7.6e-07 ps=7.6e-07 sa=1.4e-07 sb=1.4e-07 sca=20.4324 scb=0.0198648 scc=0.00175929 fw=2.4e-07 $X=-4950 $Y=-42560 $dt=1
M85 48 103 VDD VDD g45p1svt w=2.4e-07 l=4.5e-08 ad=3.36e-14 as=3.36e-14 pd=7.6e-07 ps=7.6e-07 sa=1.4e-07 sb=1.4e-07 sca=20.4324 scb=0.0198648 scc=0.00175929 fw=2.4e-07 $X=-4950 $Y=-9650 $dt=1
M86 49 96 VDD VDD g45p1svt w=2.4e-07 l=4.5e-08 ad=3.36e-14 as=3.36e-14 pd=7.6e-07 ps=7.6e-07 sa=1.4e-07 sb=1.4e-07 sca=20.4324 scb=0.0198648 scc=0.00175929 fw=2.4e-07 $X=-4950 $Y=19610 $dt=1
M87 P4 106 330 VDD g45p1svt w=4.8e-07 l=4.5e-08 ad=6.72e-14 as=6.72e-14 pd=1.24e-06 ps=1.24e-06 sa=1.4e-07 sb=1.4e-07 sca=9.47395 scb=0.00759651 scc=0.000374483 fw=4.8e-07 $X=-4920 $Y=-37080 $dt=1
M88 21 99 326 VDD g45p1svt w=4.8e-07 l=4.5e-08 ad=6.72e-14 as=6.72e-14 pd=1.24e-06 ps=1.24e-06 sa=1.4e-07 sb=1.4e-07 sca=9.47395 scb=0.00759651 scc=0.000374483 fw=4.8e-07 $X=-4920 $Y=-4170 $dt=1
M89 25 92 322 VDD g45p1svt w=4.8e-07 l=4.5e-08 ad=6.72e-14 as=6.72e-14 pd=1.24e-06 ps=1.24e-06 sa=1.4e-07 sb=1.4e-07 sca=9.47395 scb=0.00759651 scc=0.000374483 fw=4.8e-07 $X=-4920 $Y=25090 $dt=1
M90 121 PHI 337 VDD g45p1svt w=4.8e-07 l=4.5e-08 ad=6.72e-14 as=6.72e-14 pd=1.24e-06 ps=1.24e-06 sa=1.4e-07 sb=1.4e-07 sca=15.6391 scb=0.0131208 scc=0.00120734 fw=4.8e-07 $X=-3840 $Y=-18290 $dt=1
M91 118 PHI VDD VDD g45p1svt w=2.4e-07 l=4.5e-08 ad=3.36e-14 as=3.36e-14 pd=7.6e-07 ps=7.6e-07 sa=1.4e-07 sb=1.4e-07 sca=11.619 scb=0.0101937 scc=0.000351981 fw=2.4e-07 $X=-3340 $Y=5270 $dt=1
M92 338 121 VDD VDD g45p1svt w=4.8e-07 l=4.5e-08 ad=6.72e-14 as=6.72e-14 pd=1.24e-06 ps=1.24e-06 sa=1.4e-07 sb=1.4e-07 sca=16.1286 scb=0.0134283 scc=0.00129853 fw=4.8e-07 $X=-2650 $Y=-18300 $dt=1
M93 351 46 VDD VDD g45p1svt w=4.8e-07 l=4.5e-08 ad=6.72e-14 as=6.72e-14 pd=1.24e-06 ps=1.24e-06 sa=1.4e-07 sb=1.4e-07 sca=16.1286 scb=0.0134283 scc=0.00129853 fw=4.8e-07 $X=-2100 $Y=5020 $dt=1
M94 55 120 338 VDD g45p1svt w=4.8e-07 l=4.5e-08 ad=6.72e-14 as=6.72e-14 pd=1.24e-06 ps=1.24e-06 sa=1.4e-07 sb=1.4e-07 sca=15.6391 scb=0.0131208 scc=0.00120734 fw=4.8e-07 $X=-1470 $Y=-18290 $dt=1
M95 144 50 VDD VDD g45p1svt w=2.4e-07 l=4.5e-08 ad=3.36e-14 as=3.36e-14 pd=7.6e-07 ps=7.6e-07 sa=1.4e-07 sb=1.4e-07 sca=20.4324 scb=0.0198648 scc=0.00175929 fw=2.4e-07 $X=-1120 $Y=-42560 $dt=1
M96 137 45 VDD VDD g45p1svt w=2.4e-07 l=4.5e-08 ad=3.36e-14 as=3.36e-14 pd=7.6e-07 ps=7.6e-07 sa=1.4e-07 sb=1.4e-07 sca=20.4324 scb=0.0198648 scc=0.00175929 fw=2.4e-07 $X=-1120 $Y=-9650 $dt=1
M97 130 51 VDD VDD g45p1svt w=2.4e-07 l=4.5e-08 ad=3.36e-14 as=3.36e-14 pd=7.6e-07 ps=7.6e-07 sa=1.4e-07 sb=1.4e-07 sca=20.4324 scb=0.0198648 scc=0.00175929 fw=2.4e-07 $X=-1120 $Y=19610 $dt=1
M98 347 50 VDD VDD g45p1svt w=4.8e-07 l=4.5e-08 ad=6.72e-14 as=6.72e-14 pd=1.24e-06 ps=1.24e-06 sa=1.4e-07 sb=1.4e-07 sca=9.47395 scb=0.00759651 scc=0.000374483 fw=4.8e-07 $X=-990 $Y=-37080 $dt=1
M99 343 45 VDD VDD g45p1svt w=4.8e-07 l=4.5e-08 ad=6.72e-14 as=6.72e-14 pd=1.24e-06 ps=1.24e-06 sa=1.4e-07 sb=1.4e-07 sca=9.47395 scb=0.00759651 scc=0.000374483 fw=4.8e-07 $X=-990 $Y=-4170 $dt=1
M100 339 51 VDD VDD g45p1svt w=4.8e-07 l=4.5e-08 ad=6.72e-14 as=6.72e-14 pd=1.24e-06 ps=1.24e-06 sa=1.4e-07 sb=1.4e-07 sca=9.47395 scb=0.00759651 scc=0.000374483 fw=4.8e-07 $X=-990 $Y=25090 $dt=1
M101 139 52 VDD VDD g45p1svt w=2.4e-07 l=4.5e-08 ad=3.36e-14 as=3.36e-14 pd=7.6e-07 ps=7.6e-07 sa=1.4e-07 sb=1.4e-07 sca=34.1422 scb=0.0251568 scc=0.00441949 fw=2.4e-07 $X=-980 $Y=-35070 $dt=1
M102 132 53 VDD VDD g45p1svt w=2.4e-07 l=4.5e-08 ad=3.36e-14 as=3.36e-14 pd=7.6e-07 ps=7.6e-07 sa=1.4e-07 sb=1.4e-07 sca=34.1422 scb=0.0251568 scc=0.00441949 fw=2.4e-07 $X=-980 $Y=-2160 $dt=1
M103 125 54 VDD VDD g45p1svt w=2.4e-07 l=4.5e-08 ad=3.36e-14 as=3.36e-14 pd=7.6e-07 ps=7.6e-07 sa=1.4e-07 sb=1.4e-07 sca=34.1422 scb=0.0251568 scc=0.00441949 fw=2.4e-07 $X=-980 $Y=27100 $dt=1
M104 119 PHI 351 VDD g45p1svt w=4.8e-07 l=4.5e-08 ad=6.72e-14 as=6.72e-14 pd=1.24e-06 ps=1.24e-06 sa=1.4e-07 sb=1.4e-07 sca=15.6391 scb=0.0131208 scc=0.00120734 fw=4.8e-07 $X=-890 $Y=5030 $dt=1
M105 50 29 VDD VDD g45p1svt w=2.4e-07 l=4.5e-08 ad=3.36e-14 as=3.36e-14 pd=7.6e-07 ps=7.6e-07 sa=1.4e-07 sb=1.4e-07 sca=27.6029 scb=0.0286946 scc=0.00220115 fw=2.4e-07 $X=-860 $Y=-28580 $dt=1
M106 144 52 VDD VDD g45p1svt w=2.4e-07 l=4.5e-08 ad=3.36e-14 as=3.36e-14 pd=7.6e-07 ps=7.6e-07 sa=1.4e-07 sb=1.4e-07 sca=20.4324 scb=0.0198648 scc=0.00175929 fw=2.4e-07 $X=130 $Y=-42560 $dt=1
M107 137 53 VDD VDD g45p1svt w=2.4e-07 l=4.5e-08 ad=3.36e-14 as=3.36e-14 pd=7.6e-07 ps=7.6e-07 sa=1.4e-07 sb=1.4e-07 sca=20.4324 scb=0.0198648 scc=0.00175929 fw=2.4e-07 $X=130 $Y=-9650 $dt=1
M108 130 54 VDD VDD g45p1svt w=2.4e-07 l=4.5e-08 ad=3.36e-14 as=3.36e-14 pd=7.6e-07 ps=7.6e-07 sa=1.4e-07 sb=1.4e-07 sca=20.4324 scb=0.0198648 scc=0.00175929 fw=2.4e-07 $X=130 $Y=19610 $dt=1
M109 352 119 VDD VDD g45p1svt w=4.8e-07 l=4.5e-08 ad=6.72e-14 as=6.72e-14 pd=1.24e-06 ps=1.24e-06 sa=1.4e-07 sb=1.4e-07 sca=16.1286 scb=0.0134283 scc=0.00129853 fw=4.8e-07 $X=300 $Y=5020 $dt=1
M110 50 55 VDD VDD g45p1svt w=2.4e-07 l=4.5e-08 ad=3.36e-14 as=3.36e-14 pd=7.6e-07 ps=7.6e-07 sa=1.4e-07 sb=1.4e-07 sca=30.3216 scb=0.0333085 scc=0.0025237 fw=2.4e-07 $X=390 $Y=-28580 $dt=1
M111 147 PHI VDD VDD g45p1svt w=2.4e-07 l=4.5e-08 ad=3.36e-14 as=3.36e-14 pd=7.6e-07 ps=7.6e-07 sa=1.4e-07 sb=1.4e-07 sca=11.619 scb=0.0101937 scc=0.000351981 fw=2.4e-07 $X=770 $Y=-18050 $dt=1
M112 53 118 352 VDD g45p1svt w=4.8e-07 l=4.5e-08 ad=6.72e-14 as=6.72e-14 pd=1.24e-06 ps=1.24e-06 sa=1.4e-07 sb=1.4e-07 sca=15.6391 scb=0.0131208 scc=0.00120734 fw=4.8e-07 $X=1480 $Y=5030 $dt=1
M113 353 A3 VDD VDD g45p1svt w=4.8e-07 l=4.5e-08 ad=6.72e-14 as=6.72e-14 pd=1.24e-06 ps=1.24e-06 sa=1.4e-07 sb=1.4e-07 sca=16.1286 scb=0.0134283 scc=0.00129853 fw=4.8e-07 $X=2010 $Y=-18300 $dt=1
M114 148 PHI 353 VDD g45p1svt w=4.8e-07 l=4.5e-08 ad=6.72e-14 as=6.72e-14 pd=1.24e-06 ps=1.24e-06 sa=1.4e-07 sb=1.4e-07 sca=15.6391 scb=0.0131208 scc=0.00120734 fw=4.8e-07 $X=3220 $Y=-18290 $dt=1
M115 145 PHI VDD VDD g45p1svt w=2.4e-07 l=4.5e-08 ad=3.36e-14 as=3.36e-14 pd=7.6e-07 ps=7.6e-07 sa=1.4e-07 sb=1.4e-07 sca=11.619 scb=0.0101937 scc=0.000351981 fw=2.4e-07 $X=4200 $Y=5270 $dt=1
M116 354 148 VDD VDD g45p1svt w=4.8e-07 l=4.5e-08 ad=6.72e-14 as=6.72e-14 pd=1.24e-06 ps=1.24e-06 sa=1.4e-07 sb=1.4e-07 sca=16.1286 scb=0.0134283 scc=0.00129853 fw=4.8e-07 $X=4410 $Y=-18300 $dt=1
M117 54 B0 VDD VDD g45p1svt w=2.4e-07 l=4.5e-08 ad=3.36e-14 as=3.36e-14 pd=7.6e-07 ps=7.6e-07 sa=1.4e-07 sb=1.4e-07 sca=27.6029 scb=0.0286946 scc=0.00220115 fw=2.4e-07 $X=5290 $Y=40060 $dt=1
M118 355 A3 VDD VDD g45p1svt w=4.8e-07 l=4.5e-08 ad=6.72e-14 as=6.72e-14 pd=1.24e-06 ps=1.24e-06 sa=1.4e-07 sb=1.4e-07 sca=16.1286 scb=0.0134283 scc=0.00129853 fw=4.8e-07 $X=5440 $Y=5020 $dt=1
M119 143 140 VDD VDD g45p1svt w=2.4e-07 l=4.5e-08 ad=3.36e-14 as=3.36e-14 pd=7.6e-07 ps=7.6e-07 sa=1.4e-07 sb=1.4e-07 sca=20.4324 scb=0.0198648 scc=0.00175929 fw=2.4e-07 $X=5500 $Y=-42560 $dt=1
M120 136 133 VDD VDD g45p1svt w=2.4e-07 l=4.5e-08 ad=3.36e-14 as=3.36e-14 pd=7.6e-07 ps=7.6e-07 sa=1.4e-07 sb=1.4e-07 sca=20.4324 scb=0.0198648 scc=0.00175929 fw=2.4e-07 $X=5500 $Y=-9650 $dt=1
M121 129 126 VDD VDD g45p1svt w=2.4e-07 l=4.5e-08 ad=3.36e-14 as=3.36e-14 pd=7.6e-07 ps=7.6e-07 sa=1.4e-07 sb=1.4e-07 sca=20.4324 scb=0.0198648 scc=0.00175929 fw=2.4e-07 $X=5500 $Y=19610 $dt=1
M122 56 147 354 VDD g45p1svt w=4.8e-07 l=4.5e-08 ad=6.72e-14 as=6.72e-14 pd=1.24e-06 ps=1.24e-06 sa=1.4e-07 sb=1.4e-07 sca=18.4233 scb=0.0160258 scc=0.00122435 fw=4.8e-07 $X=5590 $Y=-18290 $dt=1
M123 54 A3 VDD VDD g45p1svt w=2.4e-07 l=4.5e-08 ad=3.36e-14 as=3.36e-14 pd=7.6e-07 ps=7.6e-07 sa=1.4e-07 sb=1.4e-07 sca=30.3216 scb=0.0333085 scc=0.0025237 fw=2.4e-07 $X=6540 $Y=40060 $dt=1
M124 146 PHI 355 VDD g45p1svt w=4.8e-07 l=4.5e-08 ad=6.72e-14 as=6.72e-14 pd=1.24e-06 ps=1.24e-06 sa=1.4e-07 sb=1.4e-07 sca=15.6391 scb=0.0131208 scc=0.00120734 fw=4.8e-07 $X=6650 $Y=5030 $dt=1
M125 143 47 VDD VDD g45p1svt w=2.4e-07 l=4.5e-08 ad=3.36e-14 as=3.36e-14 pd=7.6e-07 ps=7.6e-07 sa=1.4e-07 sb=1.4e-07 sca=20.4324 scb=0.0198648 scc=0.00175929 fw=2.4e-07 $X=6750 $Y=-42560 $dt=1
M126 136 48 VDD VDD g45p1svt w=2.4e-07 l=4.5e-08 ad=3.36e-14 as=3.36e-14 pd=7.6e-07 ps=7.6e-07 sa=1.4e-07 sb=1.4e-07 sca=20.4324 scb=0.0198648 scc=0.00175929 fw=2.4e-07 $X=6750 $Y=-9650 $dt=1
M127 129 49 VDD VDD g45p1svt w=2.4e-07 l=4.5e-08 ad=3.36e-14 as=3.36e-14 pd=7.6e-07 ps=7.6e-07 sa=1.4e-07 sb=1.4e-07 sca=20.4324 scb=0.0198648 scc=0.00175929 fw=2.4e-07 $X=6750 $Y=19610 $dt=1
M128 356 146 VDD VDD g45p1svt w=4.8e-07 l=4.5e-08 ad=6.72e-14 as=6.72e-14 pd=1.24e-06 ps=1.24e-06 sa=1.4e-07 sb=1.4e-07 sca=16.1286 scb=0.0134283 scc=0.00129853 fw=4.8e-07 $X=7840 $Y=5020 $dt=1
M129 66 B1 VDD VDD g45p1svt w=2.4e-07 l=4.5e-08 ad=3.36e-14 as=3.36e-14 pd=7.6e-07 ps=7.6e-07 sa=1.4e-07 sb=1.4e-07 sca=27.6029 scb=0.0286946 scc=0.00220115 fw=2.4e-07 $X=8570 $Y=33890 $dt=1
M130 58 143 VDD VDD g45p1svt w=2.4e-07 l=4.5e-08 ad=3.36e-14 as=3.36e-14 pd=7.6e-07 ps=7.6e-07 sa=1.4e-07 sb=1.4e-07 sca=20.4324 scb=0.0198648 scc=0.00175929 fw=2.4e-07 $X=8710 $Y=-42560 $dt=1
M131 59 136 VDD VDD g45p1svt w=2.4e-07 l=4.5e-08 ad=3.36e-14 as=3.36e-14 pd=7.6e-07 ps=7.6e-07 sa=1.4e-07 sb=1.4e-07 sca=20.4324 scb=0.0198648 scc=0.00175929 fw=2.4e-07 $X=8710 $Y=-9650 $dt=1
M132 60 129 VDD VDD g45p1svt w=2.4e-07 l=4.5e-08 ad=3.36e-14 as=3.36e-14 pd=7.6e-07 ps=7.6e-07 sa=1.4e-07 sb=1.4e-07 sca=20.4324 scb=0.0198648 scc=0.00175929 fw=2.4e-07 $X=8710 $Y=19610 $dt=1
M133 57 145 356 VDD g45p1svt w=4.8e-07 l=4.5e-08 ad=6.72e-14 as=6.72e-14 pd=1.24e-06 ps=1.24e-06 sa=1.4e-07 sb=1.4e-07 sca=15.6482 scb=0.0131226 scc=0.00120734 fw=4.8e-07 $X=9020 $Y=5030 $dt=1
M134 141 47 VDD VDD g45p1svt w=2.4e-07 l=4.5e-08 ad=3.36e-14 as=3.36e-14 pd=7.6e-07 ps=7.6e-07 sa=1.4e-07 sb=1.4e-07 sca=34.1422 scb=0.0251568 scc=0.00441949 fw=2.4e-07 $X=9490 $Y=-35070 $dt=1
M135 134 48 VDD VDD g45p1svt w=2.4e-07 l=4.5e-08 ad=3.36e-14 as=3.36e-14 pd=7.6e-07 ps=7.6e-07 sa=1.4e-07 sb=1.4e-07 sca=34.1422 scb=0.0251568 scc=0.00441949 fw=2.4e-07 $X=9490 $Y=-2160 $dt=1
M136 127 49 VDD VDD g45p1svt w=2.4e-07 l=4.5e-08 ad=3.36e-14 as=3.36e-14 pd=7.6e-07 ps=7.6e-07 sa=1.4e-07 sb=1.4e-07 sca=34.1422 scb=0.0251568 scc=0.00441949 fw=2.4e-07 $X=9490 $Y=27100 $dt=1
M137 66 A3 VDD VDD g45p1svt w=2.4e-07 l=4.5e-08 ad=3.36e-14 as=3.36e-14 pd=7.6e-07 ps=7.6e-07 sa=1.4e-07 sb=1.4e-07 sca=30.3216 scb=0.0333085 scc=0.0025237 fw=2.4e-07 $X=9820 $Y=33890 $dt=1
M138 58 144 VDD VDD g45p1svt w=2.4e-07 l=4.5e-08 ad=3.36e-14 as=3.36e-14 pd=7.6e-07 ps=7.6e-07 sa=1.4e-07 sb=1.4e-07 sca=20.4324 scb=0.0198648 scc=0.00175929 fw=2.4e-07 $X=9960 $Y=-42560 $dt=1
M139 59 137 VDD VDD g45p1svt w=2.4e-07 l=4.5e-08 ad=3.36e-14 as=3.36e-14 pd=7.6e-07 ps=7.6e-07 sa=1.4e-07 sb=1.4e-07 sca=20.4324 scb=0.0198648 scc=0.00175929 fw=2.4e-07 $X=9960 $Y=-9650 $dt=1
M140 60 130 VDD VDD g45p1svt w=2.4e-07 l=4.5e-08 ad=3.36e-14 as=3.36e-14 pd=7.6e-07 ps=7.6e-07 sa=1.4e-07 sb=1.4e-07 sca=20.4324 scb=0.0198648 scc=0.00175929 fw=2.4e-07 $X=9960 $Y=19610 $dt=1
M141 P5 140 350 VDD g45p1svt w=4.8e-07 l=4.5e-08 ad=6.72e-14 as=6.72e-14 pd=1.24e-06 ps=1.24e-06 sa=1.4e-07 sb=1.4e-07 sca=9.47395 scb=0.00759651 scc=0.000374483 fw=4.8e-07 $X=9990 $Y=-37080 $dt=1
M142 40 133 346 VDD g45p1svt w=4.8e-07 l=4.5e-08 ad=6.72e-14 as=6.72e-14 pd=1.24e-06 ps=1.24e-06 sa=1.4e-07 sb=1.4e-07 sca=9.47395 scb=0.00759651 scc=0.000374483 fw=4.8e-07 $X=9990 $Y=-4170 $dt=1
M143 32 126 342 VDD g45p1svt w=4.8e-07 l=4.5e-08 ad=6.72e-14 as=6.72e-14 pd=1.24e-06 ps=1.24e-06 sa=1.4e-07 sb=1.4e-07 sca=9.47395 scb=0.00759651 scc=0.000374483 fw=4.8e-07 $X=9990 $Y=25090 $dt=1
M144 63 61 VDD VDD g45p1svt w=2.4e-07 l=4.5e-08 ad=3.36e-14 as=3.36e-14 pd=7.6e-07 ps=7.6e-07 sa=1.4e-07 sb=1.4e-07 sca=25.5742 scb=0.0258063 scc=0.00214233 fw=2.4e-07 $X=11730 $Y=4370 $dt=1
M145 150 PHI VDD VDD g45p1svt w=2.4e-07 l=4.5e-08 ad=3.36e-14 as=3.36e-14 pd=7.6e-07 ps=7.6e-07 sa=1.4e-07 sb=1.4e-07 sca=15.0576 scb=0.0142053 scc=0.000386892 fw=2.4e-07 $X=11730 $Y=10980 $dt=1
M146 369 B2 VDD VDD g45p1svt w=4.8e-07 l=4.5e-08 ad=6.72e-14 as=6.72e-14 pd=1.24e-06 ps=1.24e-06 sa=1.4e-07 sb=1.4e-07 sca=16.1286 scb=0.0134283 scc=0.00129853 fw=4.8e-07 $X=12970 $Y=10730 $dt=1
M147 63 57 VDD VDD g45p1svt w=2.4e-07 l=4.5e-08 ad=3.36e-14 as=3.36e-14 pd=7.6e-07 ps=7.6e-07 sa=1.4e-07 sb=1.4e-07 sca=30.3181 scb=0.0333078 scc=0.0025237 fw=2.4e-07 $X=12980 $Y=4370 $dt=1
M148 174 62 VDD VDD g45p1svt w=2.4e-07 l=4.5e-08 ad=3.36e-14 as=3.36e-14 pd=7.6e-07 ps=7.6e-07 sa=1.4e-07 sb=1.4e-07 sca=20.4324 scb=0.0198648 scc=0.00175929 fw=2.4e-07 $X=13130 $Y=-42530 $dt=1
M149 167 63 VDD VDD g45p1svt w=2.4e-07 l=4.5e-08 ad=3.36e-14 as=3.36e-14 pd=7.6e-07 ps=7.6e-07 sa=1.4e-07 sb=1.4e-07 sca=20.4324 scb=0.0198648 scc=0.00175929 fw=2.4e-07 $X=13130 $Y=-9620 $dt=1
M150 160 VDD VDD VDD g45p1svt w=2.4e-07 l=4.5e-08 ad=3.36e-14 as=3.36e-14 pd=7.6e-07 ps=7.6e-07 sa=1.4e-07 sb=1.4e-07 sca=20.4324 scb=0.0198648 scc=0.00175929 fw=2.4e-07 $X=13130 $Y=19640 $dt=1
M151 365 62 VDD VDD g45p1svt w=4.8e-07 l=4.5e-08 ad=6.72e-14 as=6.72e-14 pd=1.24e-06 ps=1.24e-06 sa=1.4e-07 sb=1.4e-07 sca=9.47395 scb=0.00759651 scc=0.000374483 fw=4.8e-07 $X=13260 $Y=-37050 $dt=1
M152 361 63 VDD VDD g45p1svt w=4.8e-07 l=4.5e-08 ad=6.72e-14 as=6.72e-14 pd=1.24e-06 ps=1.24e-06 sa=1.4e-07 sb=1.4e-07 sca=9.47395 scb=0.00759651 scc=0.000374483 fw=4.8e-07 $X=13260 $Y=-4140 $dt=1
M153 357 VDD VDD VDD g45p1svt w=4.8e-07 l=4.5e-08 ad=6.72e-14 as=6.72e-14 pd=1.24e-06 ps=1.24e-06 sa=1.4e-07 sb=1.4e-07 sca=9.47395 scb=0.00759651 scc=0.000374483 fw=4.8e-07 $X=13260 $Y=25120 $dt=1
M154 169 64 VDD VDD g45p1svt w=2.4e-07 l=4.5e-08 ad=3.36e-14 as=3.36e-14 pd=7.6e-07 ps=7.6e-07 sa=1.4e-07 sb=1.4e-07 sca=34.1422 scb=0.0251568 scc=0.00441949 fw=2.4e-07 $X=13270 $Y=-35040 $dt=1
M155 162 65 VDD VDD g45p1svt w=2.4e-07 l=4.5e-08 ad=3.36e-14 as=3.36e-14 pd=7.6e-07 ps=7.6e-07 sa=1.4e-07 sb=1.4e-07 sca=34.1422 scb=0.0251568 scc=0.00441949 fw=2.4e-07 $X=13270 $Y=-2130 $dt=1
M156 155 66 VDD VDD g45p1svt w=2.4e-07 l=4.5e-08 ad=3.36e-14 as=3.36e-14 pd=7.6e-07 ps=7.6e-07 sa=1.4e-07 sb=1.4e-07 sca=34.1422 scb=0.0251568 scc=0.00441949 fw=2.4e-07 $X=13270 $Y=27130 $dt=1
M157 151 PHI 369 VDD g45p1svt w=4.8e-07 l=4.5e-08 ad=6.72e-14 as=6.72e-14 pd=1.24e-06 ps=1.24e-06 sa=1.4e-07 sb=1.4e-07 sca=15.6391 scb=0.0131208 scc=0.00120734 fw=4.8e-07 $X=14180 $Y=10740 $dt=1
M158 174 64 VDD VDD g45p1svt w=2.4e-07 l=4.5e-08 ad=3.36e-14 as=3.36e-14 pd=7.6e-07 ps=7.6e-07 sa=1.4e-07 sb=1.4e-07 sca=20.4324 scb=0.0198648 scc=0.00175929 fw=2.4e-07 $X=14380 $Y=-42530 $dt=1
M159 167 65 VDD VDD g45p1svt w=2.4e-07 l=4.5e-08 ad=3.36e-14 as=3.36e-14 pd=7.6e-07 ps=7.6e-07 sa=1.4e-07 sb=1.4e-07 sca=20.4324 scb=0.0198648 scc=0.00175929 fw=2.4e-07 $X=14380 $Y=-9620 $dt=1
M160 160 66 VDD VDD g45p1svt w=2.4e-07 l=4.5e-08 ad=3.36e-14 as=3.36e-14 pd=7.6e-07 ps=7.6e-07 sa=1.4e-07 sb=1.4e-07 sca=20.4324 scb=0.0198648 scc=0.00175929 fw=2.4e-07 $X=14380 $Y=19640 $dt=1
M161 370 151 VDD VDD g45p1svt w=4.8e-07 l=4.5e-08 ad=6.72e-14 as=6.72e-14 pd=1.24e-06 ps=1.24e-06 sa=1.4e-07 sb=1.4e-07 sca=16.1286 scb=0.0134283 scc=0.00129853 fw=4.8e-07 $X=15370 $Y=10730 $dt=1
M162 175 PHI VDD VDD g45p1svt w=2.4e-07 l=4.5e-08 ad=3.36e-14 as=3.36e-14 pd=7.6e-07 ps=7.6e-07 sa=1.4e-07 sb=1.4e-07 sca=15.0576 scb=0.0142053 scc=0.000386892 fw=2.4e-07 $X=15380 $Y=-18050 $dt=1
M163 61 150 370 VDD g45p1svt w=4.8e-07 l=4.5e-08 ad=6.72e-14 as=6.72e-14 pd=1.24e-06 ps=1.24e-06 sa=1.4e-07 sb=1.4e-07 sca=15.6391 scb=0.0131208 scc=0.00120734 fw=4.8e-07 $X=16550 $Y=10740 $dt=1
M164 374 34 VDD VDD g45p1svt w=4.8e-07 l=4.5e-08 ad=6.72e-14 as=6.72e-14 pd=1.24e-06 ps=1.24e-06 sa=1.4e-07 sb=1.4e-07 sca=16.1286 scb=0.0134283 scc=0.00129853 fw=4.8e-07 $X=16620 $Y=-18300 $dt=1
M165 176 PHI 374 VDD g45p1svt w=4.8e-07 l=4.5e-08 ad=6.72e-14 as=6.72e-14 pd=1.24e-06 ps=1.24e-06 sa=1.4e-07 sb=1.4e-07 sca=15.6391 scb=0.0131208 scc=0.00120734 fw=4.8e-07 $X=17830 $Y=-18290 $dt=1
M166 181 PHI VDD VDD g45p1svt w=2.4e-07 l=4.5e-08 ad=3.36e-14 as=3.36e-14 pd=7.6e-07 ps=7.6e-07 sa=1.4e-07 sb=1.4e-07 sca=15.0576 scb=0.0142053 scc=0.000386892 fw=2.4e-07 $X=17960 $Y=37340 $dt=1
M167 375 176 VDD VDD g45p1svt w=4.8e-07 l=4.5e-08 ad=6.72e-14 as=6.72e-14 pd=1.24e-06 ps=1.24e-06 sa=1.4e-07 sb=1.4e-07 sca=16.1286 scb=0.0134283 scc=0.00129853 fw=4.8e-07 $X=19020 $Y=-18300 $dt=1
M168 376 30 VDD VDD g45p1svt w=4.8e-07 l=4.5e-08 ad=6.72e-14 as=6.72e-14 pd=1.24e-06 ps=1.24e-06 sa=1.4e-07 sb=1.4e-07 sca=16.1286 scb=0.0134283 scc=0.00129853 fw=4.8e-07 $X=19200 $Y=37090 $dt=1
M169 179 PHI VDD VDD g45p1svt w=2.4e-07 l=4.5e-08 ad=3.36e-14 as=3.36e-14 pd=7.6e-07 ps=7.6e-07 sa=1.4e-07 sb=1.4e-07 sca=15.0576 scb=0.0142053 scc=0.000386892 fw=2.4e-07 $X=19260 $Y=4850 $dt=1
M170 177 PHI VDD VDD g45p1svt w=2.4e-07 l=4.5e-08 ad=3.36e-14 as=3.36e-14 pd=7.6e-07 ps=7.6e-07 sa=1.4e-07 sb=1.4e-07 sca=11.619 scb=0.0101937 scc=0.000351981 fw=2.4e-07 $X=19260 $Y=10980 $dt=1
M171 173 170 VDD VDD g45p1svt w=2.4e-07 l=4.5e-08 ad=3.36e-14 as=3.36e-14 pd=7.6e-07 ps=7.6e-07 sa=1.4e-07 sb=1.4e-07 sca=20.4324 scb=0.0198648 scc=0.00175929 fw=2.4e-07 $X=19750 $Y=-42530 $dt=1
M172 166 163 VDD VDD g45p1svt w=2.4e-07 l=4.5e-08 ad=3.36e-14 as=3.36e-14 pd=7.6e-07 ps=7.6e-07 sa=1.4e-07 sb=1.4e-07 sca=20.4324 scb=0.0198648 scc=0.00175929 fw=2.4e-07 $X=19750 $Y=-9620 $dt=1
M173 159 156 VDD VDD g45p1svt w=2.4e-07 l=4.5e-08 ad=3.36e-14 as=3.36e-14 pd=7.6e-07 ps=7.6e-07 sa=1.4e-07 sb=1.4e-07 sca=20.4324 scb=0.0198648 scc=0.00175929 fw=2.4e-07 $X=19750 $Y=19640 $dt=1
M174 P2 175 375 VDD g45p1svt w=4.8e-07 l=4.5e-08 ad=6.72e-14 as=6.72e-14 pd=1.24e-06 ps=1.24e-06 sa=1.4e-07 sb=1.4e-07 sca=18.4233 scb=0.0160258 scc=0.00122435 fw=4.8e-07 $X=20200 $Y=-18290 $dt=1
M175 182 PHI 376 VDD g45p1svt w=4.8e-07 l=4.5e-08 ad=6.72e-14 as=6.72e-14 pd=1.24e-06 ps=1.24e-06 sa=1.4e-07 sb=1.4e-07 sca=15.6391 scb=0.0131208 scc=0.00120734 fw=4.8e-07 $X=20410 $Y=37100 $dt=1
M176 380 68 VDD VDD g45p1svt w=4.8e-07 l=4.5e-08 ad=6.72e-14 as=6.72e-14 pd=1.24e-06 ps=1.24e-06 sa=1.4e-07 sb=1.4e-07 sca=16.1286 scb=0.0134283 scc=0.00129853 fw=4.8e-07 $X=20500 $Y=4600 $dt=1
M177 378 33 VDD VDD g45p1svt w=4.8e-07 l=4.5e-08 ad=6.72e-14 as=6.72e-14 pd=1.24e-06 ps=1.24e-06 sa=1.4e-07 sb=1.4e-07 sca=16.1286 scb=0.0134283 scc=0.00129853 fw=4.8e-07 $X=20500 $Y=10730 $dt=1
M178 173 58 VDD VDD g45p1svt w=2.4e-07 l=4.5e-08 ad=3.36e-14 as=3.36e-14 pd=7.6e-07 ps=7.6e-07 sa=1.4e-07 sb=1.4e-07 sca=20.4324 scb=0.0198648 scc=0.00175929 fw=2.4e-07 $X=21000 $Y=-42530 $dt=1
M179 166 59 VDD VDD g45p1svt w=2.4e-07 l=4.5e-08 ad=3.36e-14 as=3.36e-14 pd=7.6e-07 ps=7.6e-07 sa=1.4e-07 sb=1.4e-07 sca=20.4324 scb=0.0198648 scc=0.00175929 fw=2.4e-07 $X=21000 $Y=-9620 $dt=1
M180 159 60 VDD VDD g45p1svt w=2.4e-07 l=4.5e-08 ad=3.36e-14 as=3.36e-14 pd=7.6e-07 ps=7.6e-07 sa=1.4e-07 sb=1.4e-07 sca=20.4324 scb=0.0198648 scc=0.00175929 fw=2.4e-07 $X=21000 $Y=19640 $dt=1
M181 377 182 VDD VDD g45p1svt w=4.8e-07 l=4.5e-08 ad=6.72e-14 as=6.72e-14 pd=1.24e-06 ps=1.24e-06 sa=1.4e-07 sb=1.4e-07 sca=16.1286 scb=0.0134283 scc=0.00129853 fw=4.8e-07 $X=21600 $Y=37090 $dt=1
M182 180 PHI 380 VDD g45p1svt w=4.8e-07 l=4.5e-08 ad=6.72e-14 as=6.72e-14 pd=1.24e-06 ps=1.24e-06 sa=1.4e-07 sb=1.4e-07 sca=15.6391 scb=0.0131208 scc=0.00120734 fw=4.8e-07 $X=21710 $Y=4610 $dt=1
M183 178 PHI 378 VDD g45p1svt w=4.8e-07 l=4.5e-08 ad=6.72e-14 as=6.72e-14 pd=1.24e-06 ps=1.24e-06 sa=1.4e-07 sb=1.4e-07 sca=15.6391 scb=0.0131208 scc=0.00120734 fw=4.8e-07 $X=21710 $Y=10740 $dt=1
M184 69 153 373 VDD g45p1svt w=4.8e-07 l=4.5e-08 ad=6.72e-14 as=6.72e-14 pd=1.24e-06 ps=1.24e-06 sa=1.4e-07 sb=1.4e-07 sca=8.67038 scb=0.00597621 scc=0.000178408 fw=4.8e-07 $X=22620 $Y=-26130 $dt=1
M185 P0 181 377 VDD g45p1svt w=4.8e-07 l=4.5e-08 ad=6.72e-14 as=6.72e-14 pd=1.24e-06 ps=1.24e-06 sa=1.4e-07 sb=1.4e-07 sca=18.4233 scb=0.0160258 scc=0.00122435 fw=4.8e-07 $X=22780 $Y=37100 $dt=1
M186 381 180 VDD VDD g45p1svt w=4.8e-07 l=4.5e-08 ad=6.72e-14 as=6.72e-14 pd=1.24e-06 ps=1.24e-06 sa=1.4e-07 sb=1.4e-07 sca=16.1286 scb=0.0134283 scc=0.00129853 fw=4.8e-07 $X=22900 $Y=4600 $dt=1
M187 379 178 VDD VDD g45p1svt w=4.8e-07 l=4.5e-08 ad=6.72e-14 as=6.72e-14 pd=1.24e-06 ps=1.24e-06 sa=1.4e-07 sb=1.4e-07 sca=16.1286 scb=0.0134283 scc=0.00129853 fw=4.8e-07 $X=22900 $Y=10730 $dt=1
M188 67 173 VDD VDD g45p1svt w=2.4e-07 l=4.5e-08 ad=3.36e-14 as=3.36e-14 pd=7.6e-07 ps=7.6e-07 sa=1.4e-07 sb=1.4e-07 sca=20.4324 scb=0.0198648 scc=0.00175929 fw=2.4e-07 $X=22960 $Y=-42530 $dt=1
M189 64 166 VDD VDD g45p1svt w=2.4e-07 l=4.5e-08 ad=3.36e-14 as=3.36e-14 pd=7.6e-07 ps=7.6e-07 sa=1.4e-07 sb=1.4e-07 sca=20.4324 scb=0.0198648 scc=0.00175929 fw=2.4e-07 $X=22960 $Y=-9620 $dt=1
M190 68 159 VDD VDD g45p1svt w=2.4e-07 l=4.5e-08 ad=3.36e-14 as=3.36e-14 pd=7.6e-07 ps=7.6e-07 sa=1.4e-07 sb=1.4e-07 sca=20.4324 scb=0.0198648 scc=0.00175929 fw=2.4e-07 $X=22960 $Y=19640 $dt=1
M191 171 58 VDD VDD g45p1svt w=2.4e-07 l=4.5e-08 ad=3.36e-14 as=3.36e-14 pd=7.6e-07 ps=7.6e-07 sa=1.4e-07 sb=1.4e-07 sca=35.0507 scb=0.0256051 scc=0.00441982 fw=2.4e-07 $X=23740 $Y=-35040 $dt=1
M192 164 59 VDD VDD g45p1svt w=2.4e-07 l=4.5e-08 ad=3.36e-14 as=3.36e-14 pd=7.6e-07 ps=7.6e-07 sa=1.4e-07 sb=1.4e-07 sca=35.0507 scb=0.0256051 scc=0.00441982 fw=2.4e-07 $X=23740 $Y=-2130 $dt=1
M193 157 60 VDD VDD g45p1svt w=2.4e-07 l=4.5e-08 ad=3.36e-14 as=3.36e-14 pd=7.6e-07 ps=7.6e-07 sa=1.4e-07 sb=1.4e-07 sca=35.0507 scb=0.0256051 scc=0.00441982 fw=2.4e-07 $X=23740 $Y=27130 $dt=1
M194 65 179 381 VDD g45p1svt w=4.8e-07 l=4.5e-08 ad=6.72e-14 as=6.72e-14 pd=1.24e-06 ps=1.24e-06 sa=1.4e-07 sb=1.4e-07 sca=18.4233 scb=0.0160258 scc=0.00122435 fw=4.8e-07 $X=24080 $Y=4610 $dt=1
M195 P1 177 379 VDD g45p1svt w=4.8e-07 l=4.5e-08 ad=6.72e-14 as=6.72e-14 pd=1.24e-06 ps=1.24e-06 sa=1.4e-07 sb=1.4e-07 sca=18.4233 scb=0.0160258 scc=0.00122435 fw=4.8e-07 $X=24080 $Y=10740 $dt=1
M196 67 174 VDD VDD g45p1svt w=2.4e-07 l=4.5e-08 ad=3.36e-14 as=3.36e-14 pd=7.6e-07 ps=7.6e-07 sa=1.4e-07 sb=1.4e-07 sca=25.5159 scb=0.0267815 scc=0.00187996 fw=2.4e-07 $X=24210 $Y=-42530 $dt=1
M197 64 167 VDD VDD g45p1svt w=2.4e-07 l=4.5e-08 ad=3.36e-14 as=3.36e-14 pd=7.6e-07 ps=7.6e-07 sa=1.4e-07 sb=1.4e-07 sca=25.5159 scb=0.0267815 scc=0.00187996 fw=2.4e-07 $X=24210 $Y=-9620 $dt=1
M198 68 160 VDD VDD g45p1svt w=2.4e-07 l=4.5e-08 ad=3.36e-14 as=3.36e-14 pd=7.6e-07 ps=7.6e-07 sa=1.4e-07 sb=1.4e-07 sca=25.5159 scb=0.0267815 scc=0.00187996 fw=2.4e-07 $X=24210 $Y=19640 $dt=1
M199 P6 170 368 VDD g45p1svt w=4.8e-07 l=4.5e-08 ad=6.72e-14 as=6.72e-14 pd=1.24e-06 ps=1.24e-06 sa=1.4e-07 sb=1.4e-07 sca=12.8218 scb=0.0114511 scc=0.000406405 fw=4.8e-07 $X=24240 $Y=-37050 $dt=1
M200 52 163 364 VDD g45p1svt w=4.8e-07 l=4.5e-08 ad=6.72e-14 as=6.72e-14 pd=1.24e-06 ps=1.24e-06 sa=1.4e-07 sb=1.4e-07 sca=12.8218 scb=0.0114511 scc=0.000406405 fw=4.8e-07 $X=24240 $Y=-4140 $dt=1
M201 46 156 360 VDD g45p1svt w=4.8e-07 l=4.5e-08 ad=6.72e-14 as=6.72e-14 pd=1.24e-06 ps=1.24e-06 sa=1.4e-07 sb=1.4e-07 sca=12.8218 scb=0.0114511 scc=0.000406405 fw=4.8e-07 $X=24240 $Y=25120 $dt=1
.ends Multiplier_ppl

* +++++++++++++++++++++++++++++++++++++++++++++++++++++++++ *
* Sub cell: proc_el_ppl                                     *
* +++++++++++++++++++++++++++++++++++++++++++++++++++++++++ *
.subckt proc_el_ppl B3 B3P VDD B2 B2P B1 B1P B0 B0P GND
+ PHI A3 A2 A1 A0 RST RSTP A0P S7 A1P
+ A2P A3P S6 S5 S4 S3 S2 S1 S0 539
*.DEVICECLIMB
** N=605 EP=30 FDC=1137
X186 VDD GND B0 PHI B0P 208 209 540 541 443 FlipFlop $T=-38410 -51150 0 0 $X=-41820 $Y=-51550
X187 VDD GND B1 PHI B1P 210 211 542 543 445 FlipFlop $T=-30450 -51150 0 0 $X=-33860 $Y=-51550
X188 VDD GND B2 PHI B2P 212 213 544 545 447 FlipFlop $T=-22490 -51150 0 0 $X=-25900 $Y=-51550
X189 VDD GND B3 PHI B3P 214 215 546 547 449 FlipFlop $T=-14530 -51150 0 0 $X=-17940 $Y=-51550
X190 VDD GND RST PHI RSTP 216 217 548 549 451 FlipFlop $T=-6990 -51150 0 0 $X=-10400 $Y=-51550
X191 VDD GND A0 PHI A0P 230 231 556 557 463 FlipFlop $T=1270 43890 0 0 $X=-2140 $Y=43490
X192 VDD GND A1 PHI A1P 316 317 600 601 535 FlipFlop $T=24650 43840 0 0 $X=21240 $Y=43440
X193 VDD GND A2 PHI A2P 318 319 602 603 537 FlipFlop $T=32570 43840 0 0 $X=29160 $Y=43440
X194 VDD GND A3 PHI A3P 320 321 604 605 539 FlipFlop $T=39930 43840 0 0 $X=36520 $Y=43440
X195 S7 31 39 GND VDD 30 RST PHI 229 219
+ 224 227 550 555 faabs $T=11910 -54960 0 0 $X=-1900 $Y=-56400
X196 S6 40 31 GND VDD 34 RST PHI 315 305
+ 310 313 594 599 faabs $T=33840 -54960 0 0 $X=20030 $Y=-56400
X197 S5 41 40 GND VDD 37 RST PHI 303 293
+ 298 301 588 593 faabs $T=33840 -40870 0 0 $X=20030 $Y=-42310
X198 S4 42 41 GND VDD 36 RST PHI 291 281
+ 286 289 582 587 faabs $T=33840 -26780 0 0 $X=20030 $Y=-28220
X199 S3 43 42 GND VDD 35 RST PHI 279 269
+ 274 277 576 581 faabs $T=33840 -12700 0 0 $X=20030 $Y=-14140
X200 S2 44 43 GND VDD 32 RST PHI 267 257
+ 262 265 570 575 faabs $T=33840 1390 0 0 $X=20030 $Y=-50
X201 S1 45 44 GND VDD 33 RST PHI 255 245
+ 250 253 564 569 faabs $T=33840 15480 0 0 $X=20030 $Y=14040
X202 S0 GND 45 GND VDD 38 RST PHI 243 233
+ 238 241 558 563 faabs $T=33840 29570 0 0 $X=20030 $Y=28130
X203 VDD PHI A0 A1 A2 A3 B0 B3 B1 B2
+ GND 35 36 37 32 30 34 33 38 Multiplier_ppl $T=-11020 7310 0 0 $X=-41810 $Y=-39660
M0 B0P PHI 443 GND g45n1svt w=2.4e-07 l=4.5e-08 ad=3.36e-14 as=3.36e-14 pd=7.6e-07 ps=7.6e-07 sa=1.4e-07 sb=1.4e-07 sca=3.52678 scb=0.000111658 scc=3.66286e-09 fw=2.4e-07 $X=-36090 $Y=-50640 $dt=0
M1 B1P PHI 445 GND g45n1svt w=2.4e-07 l=4.5e-08 ad=3.36e-14 as=3.36e-14 pd=7.6e-07 ps=7.6e-07 sa=1.4e-07 sb=1.4e-07 sca=3.52678 scb=0.000111658 scc=3.66286e-09 fw=2.4e-07 $X=-28130 $Y=-50640 $dt=0
M2 B2P PHI 447 GND g45n1svt w=2.4e-07 l=4.5e-08 ad=3.36e-14 as=3.36e-14 pd=7.6e-07 ps=7.6e-07 sa=1.4e-07 sb=1.4e-07 sca=3.52678 scb=0.000111658 scc=3.66286e-09 fw=2.4e-07 $X=-20170 $Y=-50640 $dt=0
M3 B3P PHI 449 GND g45n1svt w=2.4e-07 l=4.5e-08 ad=3.36e-14 as=3.36e-14 pd=7.6e-07 ps=7.6e-07 sa=1.4e-07 sb=1.4e-07 sca=3.52678 scb=0.000111658 scc=3.66286e-09 fw=2.4e-07 $X=-12210 $Y=-50640 $dt=0
M4 RSTP PHI 451 GND g45n1svt w=2.4e-07 l=4.5e-08 ad=3.36e-14 as=3.36e-14 pd=7.6e-07 ps=7.6e-07 sa=1.4e-07 sb=1.4e-07 sca=3.52678 scb=0.000111658 scc=3.66286e-09 fw=2.4e-07 $X=-4670 $Y=-50640 $dt=0
M5 A0P PHI 463 GND g45n1svt w=2.4e-07 l=4.5e-08 ad=3.36e-14 as=3.36e-14 pd=7.6e-07 ps=7.6e-07 sa=1.4e-07 sb=1.4e-07 sca=3.52678 scb=0.000111658 scc=3.66286e-09 fw=2.4e-07 $X=3590 $Y=44400 $dt=0
M6 A1P PHI 535 GND g45n1svt w=2.4e-07 l=4.5e-08 ad=3.36e-14 as=3.36e-14 pd=7.6e-07 ps=7.6e-07 sa=1.4e-07 sb=1.4e-07 sca=3.52678 scb=0.000111658 scc=3.66286e-09 fw=2.4e-07 $X=26970 $Y=44350 $dt=0
M7 A2P PHI 537 GND g45n1svt w=2.4e-07 l=4.5e-08 ad=3.36e-14 as=3.36e-14 pd=7.6e-07 ps=7.6e-07 sa=1.4e-07 sb=1.4e-07 sca=3.52678 scb=0.000111658 scc=3.66286e-09 fw=2.4e-07 $X=34890 $Y=44350 $dt=0
M8 208 PHI VDD VDD g45p1svt w=2.4e-07 l=4.5e-08 ad=3.36e-14 as=3.36e-14 pd=7.6e-07 ps=7.6e-07 sa=1.4e-07 sb=1.4e-07 sca=15.0576 scb=0.0142053 scc=0.000386892 fw=2.4e-07 $X=-40910 $Y=-47990 $dt=1
M9 540 B0 VDD VDD g45p1svt w=4.8e-07 l=4.5e-08 ad=6.72e-14 as=6.72e-14 pd=1.24e-06 ps=1.24e-06 sa=1.4e-07 sb=1.4e-07 sca=16.1286 scb=0.0134283 scc=0.00129853 fw=4.8e-07 $X=-39670 $Y=-48240 $dt=1
M10 209 PHI 540 VDD g45p1svt w=4.8e-07 l=4.5e-08 ad=6.72e-14 as=6.72e-14 pd=1.24e-06 ps=1.24e-06 sa=1.4e-07 sb=1.4e-07 sca=15.6391 scb=0.0131208 scc=0.00120734 fw=4.8e-07 $X=-38460 $Y=-48230 $dt=1
M11 541 209 VDD VDD g45p1svt w=4.8e-07 l=4.5e-08 ad=6.72e-14 as=6.72e-14 pd=1.24e-06 ps=1.24e-06 sa=1.4e-07 sb=1.4e-07 sca=16.1286 scb=0.0134283 scc=0.00129853 fw=4.8e-07 $X=-37270 $Y=-48240 $dt=1
M12 B0P 208 541 VDD g45p1svt w=4.8e-07 l=4.5e-08 ad=6.72e-14 as=6.72e-14 pd=1.24e-06 ps=1.24e-06 sa=1.4e-07 sb=1.4e-07 sca=15.6391 scb=0.0131208 scc=0.00120734 fw=4.8e-07 $X=-36090 $Y=-48230 $dt=1
M13 210 PHI VDD VDD g45p1svt w=2.4e-07 l=4.5e-08 ad=3.36e-14 as=3.36e-14 pd=7.6e-07 ps=7.6e-07 sa=1.4e-07 sb=1.4e-07 sca=11.619 scb=0.0101937 scc=0.000351981 fw=2.4e-07 $X=-32950 $Y=-47990 $dt=1
M14 542 B1 VDD VDD g45p1svt w=4.8e-07 l=4.5e-08 ad=6.72e-14 as=6.72e-14 pd=1.24e-06 ps=1.24e-06 sa=1.4e-07 sb=1.4e-07 sca=16.1286 scb=0.0134283 scc=0.00129853 fw=4.8e-07 $X=-31710 $Y=-48240 $dt=1
M15 211 PHI 542 VDD g45p1svt w=4.8e-07 l=4.5e-08 ad=6.72e-14 as=6.72e-14 pd=1.24e-06 ps=1.24e-06 sa=1.4e-07 sb=1.4e-07 sca=15.6391 scb=0.0131208 scc=0.00120734 fw=4.8e-07 $X=-30500 $Y=-48230 $dt=1
M16 543 211 VDD VDD g45p1svt w=4.8e-07 l=4.5e-08 ad=6.72e-14 as=6.72e-14 pd=1.24e-06 ps=1.24e-06 sa=1.4e-07 sb=1.4e-07 sca=16.1286 scb=0.0134283 scc=0.00129853 fw=4.8e-07 $X=-29310 $Y=-48240 $dt=1
M17 B1P 210 543 VDD g45p1svt w=4.8e-07 l=4.5e-08 ad=6.72e-14 as=6.72e-14 pd=1.24e-06 ps=1.24e-06 sa=1.4e-07 sb=1.4e-07 sca=15.6391 scb=0.0131208 scc=0.00120734 fw=4.8e-07 $X=-28130 $Y=-48230 $dt=1
M18 212 PHI VDD VDD g45p1svt w=2.4e-07 l=4.5e-08 ad=3.36e-14 as=3.36e-14 pd=7.6e-07 ps=7.6e-07 sa=1.4e-07 sb=1.4e-07 sca=11.619 scb=0.0101937 scc=0.000351981 fw=2.4e-07 $X=-24990 $Y=-47990 $dt=1
M19 544 B2 VDD VDD g45p1svt w=4.8e-07 l=4.5e-08 ad=6.72e-14 as=6.72e-14 pd=1.24e-06 ps=1.24e-06 sa=1.4e-07 sb=1.4e-07 sca=16.1286 scb=0.0134283 scc=0.00129853 fw=4.8e-07 $X=-23750 $Y=-48240 $dt=1
M20 213 PHI 544 VDD g45p1svt w=4.8e-07 l=4.5e-08 ad=6.72e-14 as=6.72e-14 pd=1.24e-06 ps=1.24e-06 sa=1.4e-07 sb=1.4e-07 sca=15.6391 scb=0.0131208 scc=0.00120734 fw=4.8e-07 $X=-22540 $Y=-48230 $dt=1
M21 545 213 VDD VDD g45p1svt w=4.8e-07 l=4.5e-08 ad=6.72e-14 as=6.72e-14 pd=1.24e-06 ps=1.24e-06 sa=1.4e-07 sb=1.4e-07 sca=16.1286 scb=0.0134283 scc=0.00129853 fw=4.8e-07 $X=-21350 $Y=-48240 $dt=1
M22 B2P 212 545 VDD g45p1svt w=4.8e-07 l=4.5e-08 ad=6.72e-14 as=6.72e-14 pd=1.24e-06 ps=1.24e-06 sa=1.4e-07 sb=1.4e-07 sca=15.6391 scb=0.0131208 scc=0.00120734 fw=4.8e-07 $X=-20170 $Y=-48230 $dt=1
M23 214 PHI VDD VDD g45p1svt w=2.4e-07 l=4.5e-08 ad=3.36e-14 as=3.36e-14 pd=7.6e-07 ps=7.6e-07 sa=1.4e-07 sb=1.4e-07 sca=11.619 scb=0.0101937 scc=0.000351981 fw=2.4e-07 $X=-17030 $Y=-47990 $dt=1
M24 546 B3 VDD VDD g45p1svt w=4.8e-07 l=4.5e-08 ad=6.72e-14 as=6.72e-14 pd=1.24e-06 ps=1.24e-06 sa=1.4e-07 sb=1.4e-07 sca=16.1286 scb=0.0134283 scc=0.00129853 fw=4.8e-07 $X=-15790 $Y=-48240 $dt=1
M25 215 PHI 546 VDD g45p1svt w=4.8e-07 l=4.5e-08 ad=6.72e-14 as=6.72e-14 pd=1.24e-06 ps=1.24e-06 sa=1.4e-07 sb=1.4e-07 sca=15.6391 scb=0.0131208 scc=0.00120734 fw=4.8e-07 $X=-14580 $Y=-48230 $dt=1
M26 547 215 VDD VDD g45p1svt w=4.8e-07 l=4.5e-08 ad=6.72e-14 as=6.72e-14 pd=1.24e-06 ps=1.24e-06 sa=1.4e-07 sb=1.4e-07 sca=16.1286 scb=0.0134283 scc=0.00129853 fw=4.8e-07 $X=-13390 $Y=-48240 $dt=1
M27 B3P 214 547 VDD g45p1svt w=4.8e-07 l=4.5e-08 ad=6.72e-14 as=6.72e-14 pd=1.24e-06 ps=1.24e-06 sa=1.4e-07 sb=1.4e-07 sca=15.6391 scb=0.0131208 scc=0.00120734 fw=4.8e-07 $X=-12210 $Y=-48230 $dt=1
M28 216 PHI VDD VDD g45p1svt w=2.4e-07 l=4.5e-08 ad=3.36e-14 as=3.36e-14 pd=7.6e-07 ps=7.6e-07 sa=1.4e-07 sb=1.4e-07 sca=11.619 scb=0.0101937 scc=0.000351981 fw=2.4e-07 $X=-9490 $Y=-47990 $dt=1
M29 548 RST VDD VDD g45p1svt w=4.8e-07 l=4.5e-08 ad=6.72e-14 as=6.72e-14 pd=1.24e-06 ps=1.24e-06 sa=1.4e-07 sb=1.4e-07 sca=16.1286 scb=0.0134283 scc=0.00129853 fw=4.8e-07 $X=-8250 $Y=-48240 $dt=1
M30 217 PHI 548 VDD g45p1svt w=4.8e-07 l=4.5e-08 ad=6.72e-14 as=6.72e-14 pd=1.24e-06 ps=1.24e-06 sa=1.4e-07 sb=1.4e-07 sca=15.6391 scb=0.0131208 scc=0.00120734 fw=4.8e-07 $X=-7040 $Y=-48230 $dt=1
M31 549 217 VDD VDD g45p1svt w=4.8e-07 l=4.5e-08 ad=6.72e-14 as=6.72e-14 pd=1.24e-06 ps=1.24e-06 sa=1.4e-07 sb=1.4e-07 sca=16.1286 scb=0.0134283 scc=0.00129853 fw=4.8e-07 $X=-5850 $Y=-48240 $dt=1
M32 RSTP 216 549 VDD g45p1svt w=4.8e-07 l=4.5e-08 ad=6.72e-14 as=6.72e-14 pd=1.24e-06 ps=1.24e-06 sa=1.4e-07 sb=1.4e-07 sca=18.4233 scb=0.0160258 scc=0.00122435 fw=4.8e-07 $X=-4670 $Y=-48230 $dt=1
M33 230 PHI VDD VDD g45p1svt w=2.4e-07 l=4.5e-08 ad=3.36e-14 as=3.36e-14 pd=7.6e-07 ps=7.6e-07 sa=1.4e-07 sb=1.4e-07 sca=15.0576 scb=0.0142053 scc=0.000386892 fw=2.4e-07 $X=-1230 $Y=47050 $dt=1
M34 224 S7 VDD VDD g45p1svt w=2.4e-07 l=4.5e-08 ad=3.36e-14 as=3.36e-14 pd=7.6e-07 ps=7.6e-07 sa=1.4e-07 sb=1.4e-07 sca=15.0046 scb=0.0138563 scc=0.000630427 fw=2.4e-07 $X=-220 $Y=-52560 $dt=1
M35 550 S7 VDD VDD g45p1svt w=4.8e-07 l=4.5e-08 ad=6.72e-14 as=6.72e-14 pd=1.24e-06 ps=1.24e-06 sa=1.4e-07 sb=1.4e-07 sca=9.68014 scb=0.0076467 scc=0.00037449 fw=4.8e-07 $X=-90 $Y=-47080 $dt=1
M36 219 30 VDD VDD g45p1svt w=2.4e-07 l=4.5e-08 ad=3.36e-14 as=3.36e-14 pd=7.6e-07 ps=7.6e-07 sa=1.4e-07 sb=1.4e-07 sca=34.3359 scb=0.0252032 scc=0.0044195 fw=2.4e-07 $X=-80 $Y=-45070 $dt=1
M37 556 A0 VDD VDD g45p1svt w=4.8e-07 l=4.5e-08 ad=6.72e-14 as=6.72e-14 pd=1.24e-06 ps=1.24e-06 sa=1.4e-07 sb=1.4e-07 sca=16.1286 scb=0.0134283 scc=0.00129853 fw=4.8e-07 $X=10 $Y=46800 $dt=1
M38 231 PHI 556 VDD g45p1svt w=4.8e-07 l=4.5e-08 ad=6.72e-14 as=6.72e-14 pd=1.24e-06 ps=1.24e-06 sa=1.4e-07 sb=1.4e-07 sca=15.6391 scb=0.0131208 scc=0.00120734 fw=4.8e-07 $X=1220 $Y=46810 $dt=1
M39 557 231 VDD VDD g45p1svt w=4.8e-07 l=4.5e-08 ad=6.72e-14 as=6.72e-14 pd=1.24e-06 ps=1.24e-06 sa=1.4e-07 sb=1.4e-07 sca=16.1286 scb=0.0134283 scc=0.00129853 fw=4.8e-07 $X=2410 $Y=46800 $dt=1
M40 A0P 230 557 VDD g45p1svt w=4.8e-07 l=4.5e-08 ad=6.72e-14 as=6.72e-14 pd=1.24e-06 ps=1.24e-06 sa=1.4e-07 sb=1.4e-07 sca=18.4233 scb=0.0160258 scc=0.00122435 fw=4.8e-07 $X=3590 $Y=46810 $dt=1
M41 229 227 555 VDD g45p1svt w=4.8e-07 l=4.5e-08 ad=6.72e-14 as=6.72e-14 pd=1.24e-06 ps=1.24e-06 sa=1.4e-07 sb=1.4e-07 sca=13.3978 scb=0.0114602 scc=0.001037 fw=4.8e-07 $X=18530 $Y=-47060 $dt=1
M42 310 S6 VDD VDD g45p1svt w=2.4e-07 l=4.5e-08 ad=3.36e-14 as=3.36e-14 pd=7.6e-07 ps=7.6e-07 sa=1.4e-07 sb=1.4e-07 sca=13.9617 scb=0.0132915 scc=0.000629907 fw=2.4e-07 $X=21710 $Y=-52560 $dt=1
M43 298 S5 VDD VDD g45p1svt w=2.4e-07 l=4.5e-08 ad=3.36e-14 as=3.36e-14 pd=7.6e-07 ps=7.6e-07 sa=1.4e-07 sb=1.4e-07 sca=15.0046 scb=0.0138563 scc=0.000630427 fw=2.4e-07 $X=21710 $Y=-38470 $dt=1
M44 286 S4 VDD VDD g45p1svt w=2.4e-07 l=4.5e-08 ad=3.36e-14 as=3.36e-14 pd=7.6e-07 ps=7.6e-07 sa=1.4e-07 sb=1.4e-07 sca=15.0046 scb=0.0138563 scc=0.000630427 fw=2.4e-07 $X=21710 $Y=-24380 $dt=1
M45 274 S3 VDD VDD g45p1svt w=2.4e-07 l=4.5e-08 ad=3.36e-14 as=3.36e-14 pd=7.6e-07 ps=7.6e-07 sa=1.4e-07 sb=1.4e-07 sca=15.0046 scb=0.0138563 scc=0.000630427 fw=2.4e-07 $X=21710 $Y=-10300 $dt=1
M46 262 S2 VDD VDD g45p1svt w=2.4e-07 l=4.5e-08 ad=3.36e-14 as=3.36e-14 pd=7.6e-07 ps=7.6e-07 sa=1.4e-07 sb=1.4e-07 sca=15.0046 scb=0.0138563 scc=0.000630427 fw=2.4e-07 $X=21710 $Y=3790 $dt=1
M47 250 S1 VDD VDD g45p1svt w=2.4e-07 l=4.5e-08 ad=3.36e-14 as=3.36e-14 pd=7.6e-07 ps=7.6e-07 sa=1.4e-07 sb=1.4e-07 sca=15.0046 scb=0.0138563 scc=0.000630427 fw=2.4e-07 $X=21710 $Y=17880 $dt=1
M48 238 S0 VDD VDD g45p1svt w=2.4e-07 l=4.5e-08 ad=3.36e-14 as=3.36e-14 pd=7.6e-07 ps=7.6e-07 sa=1.4e-07 sb=1.4e-07 sca=15.0046 scb=0.0138563 scc=0.000630427 fw=2.4e-07 $X=21710 $Y=31970 $dt=1
M49 594 S6 VDD VDD g45p1svt w=4.8e-07 l=4.5e-08 ad=6.72e-14 as=6.72e-14 pd=1.24e-06 ps=1.24e-06 sa=1.4e-07 sb=1.4e-07 sca=9.47395 scb=0.00759651 scc=0.000374483 fw=4.8e-07 $X=21840 $Y=-47080 $dt=1
M50 588 S5 VDD VDD g45p1svt w=4.8e-07 l=4.5e-08 ad=6.72e-14 as=6.72e-14 pd=1.24e-06 ps=1.24e-06 sa=1.4e-07 sb=1.4e-07 sca=9.68014 scb=0.0076467 scc=0.00037449 fw=4.8e-07 $X=21840 $Y=-32990 $dt=1
M51 582 S4 VDD VDD g45p1svt w=4.8e-07 l=4.5e-08 ad=6.72e-14 as=6.72e-14 pd=1.24e-06 ps=1.24e-06 sa=1.4e-07 sb=1.4e-07 sca=9.68014 scb=0.0076467 scc=0.00037449 fw=4.8e-07 $X=21840 $Y=-18900 $dt=1
M52 576 S3 VDD VDD g45p1svt w=4.8e-07 l=4.5e-08 ad=6.72e-14 as=6.72e-14 pd=1.24e-06 ps=1.24e-06 sa=1.4e-07 sb=1.4e-07 sca=9.68014 scb=0.0076467 scc=0.00037449 fw=4.8e-07 $X=21840 $Y=-4820 $dt=1
M53 570 S2 VDD VDD g45p1svt w=4.8e-07 l=4.5e-08 ad=6.72e-14 as=6.72e-14 pd=1.24e-06 ps=1.24e-06 sa=1.4e-07 sb=1.4e-07 sca=9.68014 scb=0.0076467 scc=0.00037449 fw=4.8e-07 $X=21840 $Y=9270 $dt=1
M54 564 S1 VDD VDD g45p1svt w=4.8e-07 l=4.5e-08 ad=6.72e-14 as=6.72e-14 pd=1.24e-06 ps=1.24e-06 sa=1.4e-07 sb=1.4e-07 sca=9.68014 scb=0.0076467 scc=0.00037449 fw=4.8e-07 $X=21840 $Y=23360 $dt=1
M55 558 S0 VDD VDD g45p1svt w=4.8e-07 l=4.5e-08 ad=6.72e-14 as=6.72e-14 pd=1.24e-06 ps=1.24e-06 sa=1.4e-07 sb=1.4e-07 sca=9.68014 scb=0.0076467 scc=0.00037449 fw=4.8e-07 $X=21840 $Y=37450 $dt=1
M56 305 34 VDD VDD g45p1svt w=2.4e-07 l=4.5e-08 ad=3.36e-14 as=3.36e-14 pd=7.6e-07 ps=7.6e-07 sa=1.4e-07 sb=1.4e-07 sca=34.1422 scb=0.0251568 scc=0.00441949 fw=2.4e-07 $X=21850 $Y=-45070 $dt=1
M57 293 37 VDD VDD g45p1svt w=2.4e-07 l=4.5e-08 ad=3.36e-14 as=3.36e-14 pd=7.6e-07 ps=7.6e-07 sa=1.4e-07 sb=1.4e-07 sca=34.3359 scb=0.0252032 scc=0.0044195 fw=2.4e-07 $X=21850 $Y=-30980 $dt=1
M58 281 36 VDD VDD g45p1svt w=2.4e-07 l=4.5e-08 ad=3.36e-14 as=3.36e-14 pd=7.6e-07 ps=7.6e-07 sa=1.4e-07 sb=1.4e-07 sca=34.3359 scb=0.0252032 scc=0.0044195 fw=2.4e-07 $X=21850 $Y=-16890 $dt=1
M59 269 35 VDD VDD g45p1svt w=2.4e-07 l=4.5e-08 ad=3.36e-14 as=3.36e-14 pd=7.6e-07 ps=7.6e-07 sa=1.4e-07 sb=1.4e-07 sca=34.3359 scb=0.0252032 scc=0.0044195 fw=2.4e-07 $X=21850 $Y=-2810 $dt=1
M60 257 32 VDD VDD g45p1svt w=2.4e-07 l=4.5e-08 ad=3.36e-14 as=3.36e-14 pd=7.6e-07 ps=7.6e-07 sa=1.4e-07 sb=1.4e-07 sca=34.3359 scb=0.0252032 scc=0.0044195 fw=2.4e-07 $X=21850 $Y=11280 $dt=1
M61 245 33 VDD VDD g45p1svt w=2.4e-07 l=4.5e-08 ad=3.36e-14 as=3.36e-14 pd=7.6e-07 ps=7.6e-07 sa=1.4e-07 sb=1.4e-07 sca=34.3359 scb=0.0252032 scc=0.0044195 fw=2.4e-07 $X=21850 $Y=25370 $dt=1
M62 233 38 VDD VDD g45p1svt w=2.4e-07 l=4.5e-08 ad=3.36e-14 as=3.36e-14 pd=7.6e-07 ps=7.6e-07 sa=1.4e-07 sb=1.4e-07 sca=34.3359 scb=0.0252032 scc=0.0044195 fw=2.4e-07 $X=21850 $Y=39460 $dt=1
M63 316 PHI VDD VDD g45p1svt w=2.4e-07 l=4.5e-08 ad=3.36e-14 as=3.36e-14 pd=7.6e-07 ps=7.6e-07 sa=1.4e-07 sb=1.4e-07 sca=15.0576 scb=0.0142053 scc=0.000386892 fw=2.4e-07 $X=22150 $Y=47000 $dt=1
M64 600 A1 VDD VDD g45p1svt w=4.8e-07 l=4.5e-08 ad=6.72e-14 as=6.72e-14 pd=1.24e-06 ps=1.24e-06 sa=1.4e-07 sb=1.4e-07 sca=16.1286 scb=0.0134283 scc=0.00129853 fw=4.8e-07 $X=23390 $Y=46750 $dt=1
M65 317 PHI 600 VDD g45p1svt w=4.8e-07 l=4.5e-08 ad=6.72e-14 as=6.72e-14 pd=1.24e-06 ps=1.24e-06 sa=1.4e-07 sb=1.4e-07 sca=15.6391 scb=0.0131208 scc=0.00120734 fw=4.8e-07 $X=24600 $Y=46760 $dt=1
M66 601 317 VDD VDD g45p1svt w=4.8e-07 l=4.5e-08 ad=6.72e-14 as=6.72e-14 pd=1.24e-06 ps=1.24e-06 sa=1.4e-07 sb=1.4e-07 sca=16.1286 scb=0.0134283 scc=0.00129853 fw=4.8e-07 $X=25790 $Y=46750 $dt=1
M67 A1P 316 601 VDD g45p1svt w=4.8e-07 l=4.5e-08 ad=6.72e-14 as=6.72e-14 pd=1.24e-06 ps=1.24e-06 sa=1.4e-07 sb=1.4e-07 sca=15.6391 scb=0.0131208 scc=0.00120734 fw=4.8e-07 $X=26970 $Y=46760 $dt=1
M68 318 PHI VDD VDD g45p1svt w=2.4e-07 l=4.5e-08 ad=3.36e-14 as=3.36e-14 pd=7.6e-07 ps=7.6e-07 sa=1.4e-07 sb=1.4e-07 sca=11.619 scb=0.0101937 scc=0.000351981 fw=2.4e-07 $X=30070 $Y=47000 $dt=1
M69 602 A2 VDD VDD g45p1svt w=4.8e-07 l=4.5e-08 ad=6.72e-14 as=6.72e-14 pd=1.24e-06 ps=1.24e-06 sa=1.4e-07 sb=1.4e-07 sca=16.1286 scb=0.0134283 scc=0.00129853 fw=4.8e-07 $X=31310 $Y=46750 $dt=1
M70 319 PHI 602 VDD g45p1svt w=4.8e-07 l=4.5e-08 ad=6.72e-14 as=6.72e-14 pd=1.24e-06 ps=1.24e-06 sa=1.4e-07 sb=1.4e-07 sca=15.6391 scb=0.0131208 scc=0.00120734 fw=4.8e-07 $X=32520 $Y=46760 $dt=1
M71 603 319 VDD VDD g45p1svt w=4.8e-07 l=4.5e-08 ad=6.72e-14 as=6.72e-14 pd=1.24e-06 ps=1.24e-06 sa=1.4e-07 sb=1.4e-07 sca=16.1286 scb=0.0134283 scc=0.00129853 fw=4.8e-07 $X=33710 $Y=46750 $dt=1
M72 A2P 318 603 VDD g45p1svt w=4.8e-07 l=4.5e-08 ad=6.72e-14 as=6.72e-14 pd=1.24e-06 ps=1.24e-06 sa=1.4e-07 sb=1.4e-07 sca=15.6391 scb=0.0131208 scc=0.00120734 fw=4.8e-07 $X=34890 $Y=46760 $dt=1
M73 320 PHI VDD VDD g45p1svt w=2.4e-07 l=4.5e-08 ad=3.36e-14 as=3.36e-14 pd=7.6e-07 ps=7.6e-07 sa=1.4e-07 sb=1.4e-07 sca=11.619 scb=0.0101937 scc=0.000351981 fw=2.4e-07 $X=37430 $Y=47000 $dt=1
M74 604 A3 VDD VDD g45p1svt w=4.8e-07 l=4.5e-08 ad=6.72e-14 as=6.72e-14 pd=1.24e-06 ps=1.24e-06 sa=1.4e-07 sb=1.4e-07 sca=16.1286 scb=0.0134283 scc=0.00129853 fw=4.8e-07 $X=38670 $Y=46750 $dt=1
M75 321 PHI 604 VDD g45p1svt w=4.8e-07 l=4.5e-08 ad=6.72e-14 as=6.72e-14 pd=1.24e-06 ps=1.24e-06 sa=1.4e-07 sb=1.4e-07 sca=15.6391 scb=0.0131208 scc=0.00120734 fw=4.8e-07 $X=39880 $Y=46760 $dt=1
M76 315 313 599 VDD g45p1svt w=4.8e-07 l=4.5e-08 ad=6.72e-14 as=6.72e-14 pd=1.24e-06 ps=1.24e-06 sa=1.4e-07 sb=1.4e-07 sca=13.9023 scb=0.0116351 scc=0.00103705 fw=4.8e-07 $X=40460 $Y=-47060 $dt=1
M77 303 301 593 VDD g45p1svt w=4.8e-07 l=4.5e-08 ad=6.72e-14 as=6.72e-14 pd=1.24e-06 ps=1.24e-06 sa=1.4e-07 sb=1.4e-07 sca=13.9023 scb=0.0116351 scc=0.00103705 fw=4.8e-07 $X=40460 $Y=-32970 $dt=1
M78 291 289 587 VDD g45p1svt w=4.8e-07 l=4.5e-08 ad=6.72e-14 as=6.72e-14 pd=1.24e-06 ps=1.24e-06 sa=1.4e-07 sb=1.4e-07 sca=13.9023 scb=0.0116351 scc=0.00103705 fw=4.8e-07 $X=40460 $Y=-18880 $dt=1
M79 279 277 581 VDD g45p1svt w=4.8e-07 l=4.5e-08 ad=6.72e-14 as=6.72e-14 pd=1.24e-06 ps=1.24e-06 sa=1.4e-07 sb=1.4e-07 sca=13.9023 scb=0.0116351 scc=0.00103705 fw=4.8e-07 $X=40460 $Y=-4800 $dt=1
M80 267 265 575 VDD g45p1svt w=4.8e-07 l=4.5e-08 ad=6.72e-14 as=6.72e-14 pd=1.24e-06 ps=1.24e-06 sa=1.4e-07 sb=1.4e-07 sca=13.9023 scb=0.0116351 scc=0.00103705 fw=4.8e-07 $X=40460 $Y=9290 $dt=1
M81 255 253 569 VDD g45p1svt w=4.8e-07 l=4.5e-08 ad=6.72e-14 as=6.72e-14 pd=1.24e-06 ps=1.24e-06 sa=1.4e-07 sb=1.4e-07 sca=13.9023 scb=0.0116351 scc=0.00103705 fw=4.8e-07 $X=40460 $Y=23380 $dt=1
M82 243 241 563 VDD g45p1svt w=4.8e-07 l=4.5e-08 ad=6.72e-14 as=6.72e-14 pd=1.24e-06 ps=1.24e-06 sa=1.4e-07 sb=1.4e-07 sca=13.9023 scb=0.0116351 scc=0.00103705 fw=4.8e-07 $X=40460 $Y=37470 $dt=1
M83 605 321 VDD VDD g45p1svt w=4.8e-07 l=4.5e-08 ad=6.72e-14 as=6.72e-14 pd=1.24e-06 ps=1.24e-06 sa=1.4e-07 sb=1.4e-07 sca=16.1286 scb=0.0134283 scc=0.00129853 fw=4.8e-07 $X=41070 $Y=46750 $dt=1
M84 A3P 320 605 VDD g45p1svt w=4.8e-07 l=4.5e-08 ad=6.72e-14 as=6.72e-14 pd=1.24e-06 ps=1.24e-06 sa=1.4e-07 sb=1.4e-07 sca=18.4233 scb=0.0160258 scc=0.00122435 fw=4.8e-07 $X=42250 $Y=46760 $dt=1
.ends proc_el_ppl

* +++++++++++++++++++++++++++++++++++++++++++++++++++++++++ *
* Sub cell: MASCO__A1                                       *
* +++++++++++++++++++++++++++++++++++++++++++++++++++++++++ *
.subckt MASCO__A1 1 2 3 4 5 6 7 8 9 10
+ 11 12 13 14 15 16 17 18 19 20
+ 21 22 23 24 25 26 27 28 29 30
+ 31 32 33 34 35 36 37 38 39 40
+ 41 42 43 44 45 46 1070
*.DEVICECLIMB
** N=1070 EP=47 FDC=2275
X0 4 35 5 3 36 2 37 1 38 6
+ 8 9 10 11 12 7 14 47 13 48
+ 49 50 25 24 23 22 21 20 19 851 proc_el_ppl $T=43310 57270 0 0 $X=0 $Y=0
X1 18 39 5 17 40 16 41 15 42 6
+ 8 50 49 48 47 14 26 43 34 44
+ 46 45 33 32 31 30 29 28 27 1070 proc_el_ppl $T=130540 57270 0 0 $X=87230 $Y=0
M0 50 8 851 6 g45n1svt w=2.4e-07 l=4.5e-08 ad=3.36e-14 as=3.36e-14 pd=7.6e-07 ps=7.6e-07 sa=1.4e-07 sb=1.4e-07 sca=3.52678 scb=0.000111658 scc=3.66286e-09 fw=2.4e-07 $X=85560 $Y=101620 $dt=0
.ends MASCO__A1

* +++++++++++++++++++++++++++++++++++++++++++++++++++++++++ *
* Sub cell: sys_arr_ppl                                     *
* +++++++++++++++++++++++++++++++++++++++++++++++++++++++++ *
.subckt sys_arr_ppl A00_0 A00_1 A00_2 A00_3 A01_0 A01_1 A01_2 A01_3 A02_0 A02_1
+ A02_2 A02_3 A03_0 A03_1 A03_2 A03_3 B00_0 B00_1 B00_2 B00_3
+ B10_0 B10_1 B10_2 B10_3 B20_0 B20_1 B20_2 B20_3 B30_0 B30_1
+ B30_2 B30_3 GND PHI RST S00_0 S00_1 S00_2 S00_3 S00_4
+ S00_5 S00_6 S00_7 S01_0 S01_1 S01_2 S01_3 S01_4 S01_5 S01_6
+ S01_7 S02_0 S02_1 S02_2 S02_3 S02_4 S02_5 S02_6 S02_7 S03_0
+ S03_1 S03_2 S03_3 S03_4 S03_5 S03_6 S03_7 S10_0 S10_1 S10_2
+ S10_3 S10_4 S10_5 S10_6 S10_7 S11_0 S11_1 S11_2 S11_3 S11_4
+ S11_5 S11_6 S11_7 S12_0 S12_1 S12_2 S12_3 S12_4 S12_5 S12_6
+ S12_7 S13_0 S13_1 S13_2 S13_3 S13_4 S13_5 S13_6 S13_7 S20_0
+ S20_1 S20_2 S20_3 S20_4 S20_5 S20_6 S20_7 S21_0 S21_1 S21_2
+ S21_3 S21_4 S21_5 S21_6 S21_7 S22_0 S22_1 S22_2 S22_3 S22_4
+ S22_5 S22_6 S22_7 S23_0 S23_1 S23_2 S23_3 S23_4 S23_5 S23_6
+ S23_7 S30_0 S30_1 S30_2 S30_3 S30_4 S30_5 S30_6 S30_7 S31_0
+ S31_1 S31_2 S31_3 S31_4 S31_5 S31_6 S31_7 S32_0 S32_1 S32_2
+ S32_3 S32_4 S32_5 S32_6 S32_7 S33_0 S33_1 S33_2 S33_3 S33_4
+ S33_5 S33_6 S33_7 VDD
** N=8468 EP=164 FDC=18208
X6 4 5 6 7 VDD GND 1 PHI A03_3 A03_2
+ A03_1 A03_0 S03_7 16 17 18 19 20 S03_0 S03_1
+ S03_2 S03_3 S03_4 S03_5 S03_6 28 S13_0 S13_1 S13_2 S13_3
+ S13_4 S13_5 S13_6 S13_7 37 38 39 40 41 42
+ 43 44 45 46 47 48 5402 MASCO__A1 $T=-54450 -387070 0 0 $X=-54450 $Y=-387070
X7 49 50 51 52 VDD GND 3 PHI A02_3 A02_2
+ A02_1 A02_0 S02_7 1 58 59 60 61 S02_0 S02_1
+ S02_2 S02_3 S02_4 S02_5 S02_6 69 S12_0 S12_1 S12_2 S12_3
+ S12_4 S12_5 S12_6 S12_7 7 6 5 4 20 19
+ 18 17 78 79 80 81 5840 MASCO__A1 $T=-54450 -278050 0 0 $X=-54450 $Y=-278050
X8 82 83 84 85 VDD GND 2 PHI A01_3 A01_2
+ A01_1 A01_0 S01_7 3 91 92 93 94 S01_0 S01_1
+ S01_2 S01_3 S01_4 S01_5 S01_6 102 S11_0 S11_1 S11_2 S11_3
+ S11_4 S11_5 S11_6 S11_7 52 51 50 49 61 60
+ 59 58 111 112 113 114 6278 MASCO__A1 $T=-54450 -169060 0 0 $X=-54450 $Y=-169060
X9 B00_0 B00_1 B00_2 B00_3 VDD GND RST PHI A00_3 A00_2
+ A00_1 A00_0 S00_7 2 B10_0 B10_1 B10_2 B10_3 S00_0 S00_1
+ S00_2 S00_3 S00_4 S00_5 S00_6 136 S10_0 S10_1 S10_2 S10_3
+ S10_4 S10_5 S10_6 S10_7 85 84 83 82 94 93
+ 92 91 145 146 147 148 6716 MASCO__A1 $T=-54450 -60040 0 0 $X=-54450 $Y=-60040
X10 149 150 151 152 VDD GND 28 PHI 47 48
+ 46 45 S23_7 154 155 156 157 158 S23_0 S23_1
+ S23_2 S23_3 S23_4 S23_5 S23_6 166 S33_0 S33_1 S33_2 S33_3
+ S33_4 S33_5 S33_6 S33_7 175 176 177 178 179 180
+ 181 182 183 184 185 186 7154 MASCO__A1 $T=120010 -387070 0 0 $X=120010 $Y=-387070
X11 187 188 189 190 VDD GND 69 PHI 80 81
+ 79 78 S22_7 192 193 194 195 196 S22_0 S22_1
+ S22_2 S22_3 S22_4 S22_5 S22_6 204 S32_0 S32_1 S32_2 S32_3
+ S32_4 S32_5 S32_6 S32_7 152 151 150 149 158 157
+ 156 155 213 214 215 216 7592 MASCO__A1 $T=120010 -278050 0 0 $X=120010 $Y=-278050
X12 217 218 219 220 VDD GND 102 PHI 113 114
+ 112 111 S21_7 222 223 224 225 226 S21_0 S21_1
+ S21_2 S21_3 S21_4 S21_5 S21_6 234 S31_0 S31_1 S31_2 S31_3
+ S31_4 S31_5 S31_6 S31_7 190 189 188 187 196 195
+ 194 193 243 244 245 246 8030 MASCO__A1 $T=120010 -169060 0 0 $X=120010 $Y=-169060
X13 B20_0 B20_1 B20_2 B20_3 VDD GND 136 PHI 147 148
+ 146 145 S20_7 252 B30_0 B30_1 B30_2 B30_3 S20_0 S20_1
+ S20_2 S20_3 S20_4 S20_5 S20_6 264 S30_0 S30_1 S30_2 S30_3
+ S30_4 S30_5 S30_6 S30_7 220 219 218 217 226 225
+ 224 223 273 274 275 276 8468 MASCO__A1 $T=120010 -60040 0 0 $X=120010 $Y=-60040
M0 47 PHI 5402 GND g45n1svt w=2.4e-07 l=4.5e-08 ad=3.36e-14 as=3.36e-14 pd=7.6e-07 ps=7.6e-07 sa=1.4e-07 sb=1.4e-07 sca=3.52678 scb=0.000111658 scc=3.66286e-09 fw=2.4e-07 $X=118340 $Y=-285450 $dt=0
M1 80 PHI 5840 GND g45n1svt w=2.4e-07 l=4.5e-08 ad=3.36e-14 as=3.36e-14 pd=7.6e-07 ps=7.6e-07 sa=1.4e-07 sb=1.4e-07 sca=3.52678 scb=0.000111658 scc=3.66286e-09 fw=2.4e-07 $X=118340 $Y=-176430 $dt=0
M2 113 PHI 6278 GND g45n1svt w=2.4e-07 l=4.5e-08 ad=3.36e-14 as=3.36e-14 pd=7.6e-07 ps=7.6e-07 sa=1.4e-07 sb=1.4e-07 sca=3.52678 scb=0.000111658 scc=3.66286e-09 fw=2.4e-07 $X=118340 $Y=-67440 $dt=0
M3 147 PHI 6716 GND g45n1svt w=2.4e-07 l=4.5e-08 ad=3.36e-14 as=3.36e-14 pd=7.6e-07 ps=7.6e-07 sa=1.4e-07 sb=1.4e-07 sca=3.52678 scb=0.000111658 scc=3.66286e-09 fw=2.4e-07 $X=118340 $Y=41580 $dt=0
M4 185 PHI 7154 GND g45n1svt w=2.4e-07 l=4.5e-08 ad=3.36e-14 as=3.36e-14 pd=7.6e-07 ps=7.6e-07 sa=1.4e-07 sb=1.4e-07 sca=3.97968 scb=0.000260302 scc=4.40173e-08 fw=2.4e-07 $X=292800 $Y=-285450 $dt=0
M5 215 PHI 7592 GND g45n1svt w=2.4e-07 l=4.5e-08 ad=3.36e-14 as=3.36e-14 pd=7.6e-07 ps=7.6e-07 sa=1.4e-07 sb=1.4e-07 sca=3.97968 scb=0.000260302 scc=4.40173e-08 fw=2.4e-07 $X=292800 $Y=-176430 $dt=0
M6 245 PHI 8030 GND g45n1svt w=2.4e-07 l=4.5e-08 ad=3.36e-14 as=3.36e-14 pd=7.6e-07 ps=7.6e-07 sa=1.4e-07 sb=1.4e-07 sca=3.97968 scb=0.000260302 scc=4.40173e-08 fw=2.4e-07 $X=292800 $Y=-67440 $dt=0
M7 275 PHI 8468 GND g45n1svt w=2.4e-07 l=4.5e-08 ad=3.36e-14 as=3.36e-14 pd=7.6e-07 ps=7.6e-07 sa=1.4e-07 sb=1.4e-07 sca=3.97968 scb=0.000260302 scc=4.40173e-08 fw=2.4e-07 $X=292800 $Y=41580 $dt=0
.ends sys_arr_ppl
